* NGSPICE file created from sample_pads.ext - technology: gf180mcuD

.subckt pmos_6p0_CDNS_406619531455 w_n208_n120# D a_5124_n44# a_3904_n44# a_5368_n44#
+ a_4392_n44# a_2928_n44# a_1952_n44# a_4148_n44# a_3172_n44# a_1708_n44# a_2196_n44#
+ a_732_n44# a_976_n44# a_0_n44# a_5612_n44# a_4880_n44# S a_4636_n44# a_3660_n44#
+ a_3416_n44# a_2440_n44# a_2684_n44# a_1220_n44# a_1464_n44# a_244_n44# a_488_n44#
X0 S a_2196_n44# D w_n208_n120# pfet_05v0 ad=1.3p pd=5.52u as=1.3p ps=5.52u w=5u l=0.7u
X1 S a_1708_n44# D w_n208_n120# pfet_05v0 ad=1.3p pd=5.52u as=1.3p ps=5.52u w=5u l=0.7u
X2 S a_3172_n44# D w_n208_n120# pfet_05v0 ad=1.3p pd=5.52u as=1.3p ps=5.52u w=5u l=0.7u
X3 S a_4148_n44# D w_n208_n120# pfet_05v0 ad=1.3p pd=5.52u as=1.3p ps=5.52u w=5u l=0.7u
X4 D a_1952_n44# S w_n208_n120# pfet_05v0 ad=1.3p pd=5.52u as=1.3p ps=5.52u w=5u l=0.7u
X5 D a_2928_n44# S w_n208_n120# pfet_05v0 ad=1.3p pd=5.52u as=1.3p ps=5.52u w=5u l=0.7u
X6 D a_4392_n44# S w_n208_n120# pfet_05v0 ad=1.3p pd=5.52u as=1.3p ps=5.52u w=5u l=0.7u
X7 D a_5368_n44# S w_n208_n120# pfet_05v0 ad=1.3p pd=5.52u as=1.3p ps=5.52u w=5u l=0.7u
X8 D a_3904_n44# S w_n208_n120# pfet_05v0 ad=1.3p pd=5.52u as=1.3p ps=5.52u w=5u l=0.7u
X9 S a_5124_n44# D w_n208_n120# pfet_05v0 ad=1.3p pd=5.52u as=1.3p ps=5.52u w=5u l=0.7u
X10 D a_976_n44# S w_n208_n120# pfet_05v0 ad=1.3p pd=5.52u as=1.3p ps=5.52u w=5u l=0.7u
X11 S a_732_n44# D w_n208_n120# pfet_05v0 ad=1.3p pd=5.52u as=1.3p ps=5.52u w=5u l=0.7u
X12 D a_1464_n44# S w_n208_n120# pfet_05v0 ad=1.3p pd=5.52u as=1.3p ps=5.52u w=5u l=0.7u
X13 S a_1220_n44# D w_n208_n120# pfet_05v0 ad=1.3p pd=5.52u as=1.3p ps=5.52u w=5u l=0.7u
X14 S a_2684_n44# D w_n208_n120# pfet_05v0 ad=1.3p pd=5.52u as=1.3p ps=5.52u w=5u l=0.7u
X15 D a_2440_n44# S w_n208_n120# pfet_05v0 ad=1.3p pd=5.52u as=1.3p ps=5.52u w=5u l=0.7u
X16 D a_3416_n44# S w_n208_n120# pfet_05v0 ad=1.3p pd=5.52u as=1.3p ps=5.52u w=5u l=0.7u
X17 S a_3660_n44# D w_n208_n120# pfet_05v0 ad=1.3p pd=5.52u as=1.3p ps=5.52u w=5u l=0.7u
X18 S a_4636_n44# D w_n208_n120# pfet_05v0 ad=1.3p pd=5.52u as=1.3p ps=5.52u w=5u l=0.7u
X19 D a_4880_n44# S w_n208_n120# pfet_05v0 ad=1.3p pd=5.52u as=1.3p ps=5.52u w=5u l=0.7u
X20 S a_5612_n44# D w_n208_n120# pfet_05v0 ad=2.2p pd=10.88u as=1.3p ps=5.52u w=5u l=0.7u
X21 S a_244_n44# D w_n208_n120# pfet_05v0 ad=1.3p pd=5.52u as=1.3p ps=5.52u w=5u l=0.7u
X22 D a_488_n44# S w_n208_n120# pfet_05v0 ad=1.3p pd=5.52u as=1.3p ps=5.52u w=5u l=0.7u
X23 D a_0_n44# S w_n208_n120# pfet_05v0 ad=1.3p pd=5.52u as=2.2p ps=10.88u w=5u l=0.7u
.ends

.subckt nmos_6p0_CDNS_406619531459 D a_0_n44# S VSUBS
X0 D a_0_n44# S VSUBS nfet_05v0 ad=2.2p pd=10.88u as=2.2p ps=10.88u w=5u l=0.7u
.ends

.subckt pmos_6p0_CDNS_406619531456 w_n208_n120# D a_0_n44# S a_244_n44# a_488_n44#
X0 S a_244_n44# D w_n208_n120# pfet_05v0 ad=1.3p pd=5.52u as=1.3p ps=5.52u w=5u l=0.7u
X1 D a_488_n44# S w_n208_n120# pfet_05v0 ad=2.2p pd=10.88u as=1.3p ps=5.52u w=5u l=0.7u
X2 D a_0_n44# S w_n208_n120# pfet_05v0 ad=1.3p pd=5.52u as=2.2p ps=10.88u w=5u l=0.7u
.ends

.subckt ppolyf_u_CDNS_406619531453 PLUS MINUS VSUBS
X0 PLUS MINUS VSUBS ppolyf_u r_width=0.8u r_length=63.855u
.ends

.subckt comp018green_esd_rc_v5p0 ppolyf_u_CDNS_406619531453_10/MINUS ppolyf_u_CDNS_406619531453_3/PLUS
+ ppolyf_u_CDNS_406619531453_11/MINUS ppolyf_u_CDNS_406619531453_0/PLUS ppolyf_u_CDNS_406619531453_11/PLUS
+ ppolyf_u_CDNS_406619531453_0/MINUS ppolyf_u_CDNS_406619531453_7/PLUS ppolyf_u_CDNS_406619531453_1/MINUS
+ ppolyf_u_CDNS_406619531453_2/MINUS ppolyf_u_CDNS_406619531453_3/MINUS ppolyf_u_CDNS_406619531453_4/PLUS
+ ppolyf_u_CDNS_406619531453_4/MINUS ppolyf_u_CDNS_406619531453_5/MINUS M1_NWELL_CDNS_40661953145128_1/w_n128_n1844#
+ ppolyf_u_CDNS_406619531453_1/PLUS ppolyf_u_CDNS_406619531453_6/MINUS ppolyf_u_CDNS_406619531453_7/MINUS
+ ppolyf_u_CDNS_406619531453_8/MINUS ppolyf_u_CDNS_406619531453_9/MINUS ppolyf_u_CDNS_406619531453_8/PLUS
+ ppolyf_u_CDNS_406619531453_5/PLUS ppolyf_u_CDNS_406619531453_2/PLUS ppolyf_u_CDNS_406619531453_10/PLUS
+ ppolyf_u_CDNS_406619531453_9/PLUS ppolyf_u_CDNS_406619531453_6/PLUS VSUBS
Xppolyf_u_CDNS_406619531453_0 ppolyf_u_CDNS_406619531453_0/PLUS ppolyf_u_CDNS_406619531453_0/MINUS
+ VSUBS ppolyf_u_CDNS_406619531453
Xppolyf_u_CDNS_406619531453_1 ppolyf_u_CDNS_406619531453_1/PLUS ppolyf_u_CDNS_406619531453_1/MINUS
+ VSUBS ppolyf_u_CDNS_406619531453
Xppolyf_u_CDNS_406619531453_2 ppolyf_u_CDNS_406619531453_2/PLUS ppolyf_u_CDNS_406619531453_2/MINUS
+ VSUBS ppolyf_u_CDNS_406619531453
Xppolyf_u_CDNS_406619531453_3 ppolyf_u_CDNS_406619531453_3/PLUS ppolyf_u_CDNS_406619531453_3/MINUS
+ VSUBS ppolyf_u_CDNS_406619531453
Xppolyf_u_CDNS_406619531453_4 ppolyf_u_CDNS_406619531453_4/PLUS ppolyf_u_CDNS_406619531453_4/MINUS
+ VSUBS ppolyf_u_CDNS_406619531453
Xppolyf_u_CDNS_406619531453_5 ppolyf_u_CDNS_406619531453_5/PLUS ppolyf_u_CDNS_406619531453_5/MINUS
+ VSUBS ppolyf_u_CDNS_406619531453
Xppolyf_u_CDNS_406619531453_6 ppolyf_u_CDNS_406619531453_6/PLUS ppolyf_u_CDNS_406619531453_6/MINUS
+ VSUBS ppolyf_u_CDNS_406619531453
Xppolyf_u_CDNS_406619531453_7 ppolyf_u_CDNS_406619531453_7/PLUS ppolyf_u_CDNS_406619531453_7/MINUS
+ VSUBS ppolyf_u_CDNS_406619531453
Xppolyf_u_CDNS_406619531453_8 ppolyf_u_CDNS_406619531453_8/PLUS ppolyf_u_CDNS_406619531453_8/MINUS
+ VSUBS ppolyf_u_CDNS_406619531453
Xppolyf_u_CDNS_406619531453_9 ppolyf_u_CDNS_406619531453_9/PLUS ppolyf_u_CDNS_406619531453_9/MINUS
+ VSUBS ppolyf_u_CDNS_406619531453
Xppolyf_u_CDNS_406619531453_10 ppolyf_u_CDNS_406619531453_10/PLUS ppolyf_u_CDNS_406619531453_10/MINUS
+ VSUBS ppolyf_u_CDNS_406619531453
Xppolyf_u_CDNS_406619531453_11 ppolyf_u_CDNS_406619531453_11/PLUS ppolyf_u_CDNS_406619531453_11/MINUS
+ VSUBS ppolyf_u_CDNS_406619531453
.ends

.subckt pmos_6p0_CDNS_406619531452 w_n208_n120# D a_732_n44# a_0_n44# S a_244_n44#
+ a_488_n44#
X0 S a_732_n44# D w_n208_n120# pfet_05v0 ad=2.2p pd=10.88u as=1.3p ps=5.52u w=5u l=0.7u
X1 S a_244_n44# D w_n208_n120# pfet_05v0 ad=1.3p pd=5.52u as=1.3p ps=5.52u w=5u l=0.7u
X2 D a_488_n44# S w_n208_n120# pfet_05v0 ad=1.3p pd=5.52u as=1.3p ps=5.52u w=5u l=0.7u
X3 D a_0_n44# S w_n208_n120# pfet_05v0 ad=1.3p pd=5.52u as=2.2p ps=10.88u w=5u l=0.7u
.ends

.subckt nmos_6p0_CDNS_406619531457 D a_3904_n44# a_4392_n44# a_2928_n44# a_1952_n44#
+ a_4148_n44# a_3172_n44# a_1708_n44# a_2196_n44# a_732_n44# a_976_n44# a_0_n44# S
+ a_4636_n44# a_3660_n44# a_3416_n44# a_2440_n44# a_2684_n44# a_1220_n44# a_1464_n44#
+ a_244_n44# a_488_n44# VSUBS
X0 S a_1708_n44# D VSUBS nfet_05v0 ad=13p pd=50.52u as=13p ps=50.52u w=50u l=0.7u
X1 D a_1952_n44# S VSUBS nfet_05v0 ad=13p pd=50.52u as=13p ps=50.52u w=50u l=0.7u
X2 D a_2928_n44# S VSUBS nfet_05v0 ad=13p pd=50.52u as=13p ps=50.52u w=50u l=0.7u
X3 S a_3172_n44# D VSUBS nfet_05v0 ad=13p pd=50.52u as=13p ps=50.52u w=50u l=0.7u
X4 S a_4148_n44# D VSUBS nfet_05v0 ad=13p pd=50.52u as=13p ps=50.52u w=50u l=0.7u
X5 D a_3904_n44# S VSUBS nfet_05v0 ad=13p pd=50.52u as=13p ps=50.52u w=50u l=0.7u
X6 D a_4392_n44# S VSUBS nfet_05v0 ad=13p pd=50.52u as=13p ps=50.52u w=50u l=0.7u
X7 D a_976_n44# S VSUBS nfet_05v0 ad=13p pd=50.52u as=13p ps=50.52u w=50u l=0.7u
X8 S a_732_n44# D VSUBS nfet_05v0 ad=13p pd=50.52u as=13p ps=50.52u w=50u l=0.7u
X9 D a_1464_n44# S VSUBS nfet_05v0 ad=13p pd=50.52u as=13p ps=50.52u w=50u l=0.7u
X10 S a_1220_n44# D VSUBS nfet_05v0 ad=13p pd=50.52u as=13p ps=50.52u w=50u l=0.7u
X11 S a_2684_n44# D VSUBS nfet_05v0 ad=13p pd=50.52u as=13p ps=50.52u w=50u l=0.7u
X12 D a_2440_n44# S VSUBS nfet_05v0 ad=13p pd=50.52u as=13p ps=50.52u w=50u l=0.7u
X13 D a_3416_n44# S VSUBS nfet_05v0 ad=13p pd=50.52u as=13p ps=50.52u w=50u l=0.7u
X14 S a_3660_n44# D VSUBS nfet_05v0 ad=13p pd=50.52u as=13p ps=50.52u w=50u l=0.7u
X15 S a_4636_n44# D VSUBS nfet_05v0 ad=22p pd=0.10088m as=13p ps=50.52u w=50u l=0.7u
X16 S a_244_n44# D VSUBS nfet_05v0 ad=13p pd=50.52u as=13p ps=50.52u w=50u l=0.7u
X17 D a_488_n44# S VSUBS nfet_05v0 ad=13p pd=50.52u as=13p ps=50.52u w=50u l=0.7u
X18 D a_0_n44# S VSUBS nfet_05v0 ad=13p pd=50.52u as=22p ps=0.10088m w=50u l=0.7u
X19 S a_2196_n44# D VSUBS nfet_05v0 ad=13p pd=50.52u as=13p ps=50.52u w=50u l=0.7u
.ends

.subckt nmos_clamp_20_50_4_DVSS nmos_6p0_CDNS_406619531457_2/a_732_n44# nmos_6p0_CDNS_406619531457_3/a_0_n44#
+ nmos_6p0_CDNS_406619531457_2/a_976_n44# M2_M1_CDNS_40661953145136_7/m1_n92_n2414#
+ M2_M1_CDNS_40661953145136_2/m1_n92_n2414# nmos_6p0_CDNS_406619531457_0/a_3660_n44#
+ nmos_6p0_CDNS_406619531457_0/a_4636_n44# nmos_6p0_CDNS_406619531457_1/a_3660_n44#
+ nmos_6p0_CDNS_406619531457_1/a_4636_n44# nmos_6p0_CDNS_406619531457_0/a_2440_n44#
+ nmos_6p0_CDNS_406619531457_0/a_3416_n44# nmos_6p0_CDNS_406619531457_3/a_732_n44#
+ nmos_6p0_CDNS_406619531457_2/a_4636_n44# nmos_6p0_CDNS_406619531457_2/a_3660_n44#
+ nmos_6p0_CDNS_406619531457_0/a_0_n44# nmos_6p0_CDNS_406619531457_0/a_2684_n44# nmos_6p0_CDNS_406619531457_1/a_2440_n44#
+ nmos_6p0_CDNS_406619531457_1/a_3416_n44# nmos_6p0_CDNS_406619531457_0/a_1220_n44#
+ nmos_6p0_CDNS_406619531457_3/a_976_n44# nmos_6p0_CDNS_406619531457_3/a_3660_n44#
+ nmos_6p0_CDNS_406619531457_3/a_4636_n44# nmos_6p0_CDNS_406619531457_2/a_3416_n44#
+ nmos_6p0_CDNS_406619531457_2/a_2440_n44# nmos_6p0_CDNS_406619531457_1/a_2684_n44#
+ nmos_6p0_CDNS_406619531457_0/a_1464_n44# nmos_6p0_CDNS_406619531457_1/a_1220_n44#
+ nmos_6p0_CDNS_406619531457_2/a_2684_n44# nmos_6p0_CDNS_406619531457_1/a_1464_n44#
+ nmos_6p0_CDNS_406619531457_3/a_2440_n44# nmos_6p0_CDNS_406619531457_3/a_3416_n44#
+ nmos_6p0_CDNS_406619531457_2/a_1220_n44# nmos_6p0_CDNS_406619531457_3/a_2684_n44#
+ nmos_6p0_CDNS_406619531457_2/a_1464_n44# nmos_6p0_CDNS_406619531457_3/S nmos_6p0_CDNS_406619531457_3/a_1220_n44#
+ nmos_6p0_CDNS_406619531457_3/a_1464_n44# M2_M1_CDNS_40661953145136_6/m1_n92_n2414#
+ M2_M1_CDNS_40661953145136_1/m1_n92_n2414# nmos_6p0_CDNS_406619531457_0/a_244_n44#
+ nmos_6p0_CDNS_406619531457_0/a_488_n44# nmos_6p0_CDNS_406619531457_1/a_0_n44# M2_M1_CDNS_40661953145136_5/m1_n92_n2414#
+ M2_M1_CDNS_40661953145136_0/m1_n92_n2414# nmos_6p0_CDNS_406619531457_1/a_244_n44#
+ nmos_6p0_CDNS_406619531457_1/a_488_n44# nmos_6p0_CDNS_406619531457_2/a_244_n44#
+ nmos_6p0_CDNS_406619531457_0/a_3904_n44# nmos_6p0_CDNS_406619531457_1/a_3904_n44#
+ nmos_6p0_CDNS_406619531457_2/a_488_n44# nmos_6p0_CDNS_406619531457_0/a_4392_n44#
+ nmos_6p0_CDNS_406619531457_2/a_3904_n44# nmos_6p0_CDNS_406619531457_0/a_2928_n44#
+ nmos_6p0_CDNS_406619531457_0/a_1952_n44# nmos_6p0_CDNS_406619531457_1/a_4392_n44#
+ nmos_6p0_CDNS_406619531457_0/a_4148_n44# nmos_6p0_CDNS_406619531457_0/a_3172_n44#
+ nmos_6p0_CDNS_406619531457_3/a_3904_n44# nmos_6p0_CDNS_406619531457_2/a_4392_n44#
+ nmos_6p0_CDNS_406619531457_1/a_1952_n44# nmos_6p0_CDNS_406619531457_1/a_2928_n44#
+ nmos_6p0_CDNS_406619531457_0/a_1708_n44# nmos_6p0_CDNS_406619531457_1/a_4148_n44#
+ nmos_6p0_CDNS_406619531457_1/a_3172_n44# nmos_6p0_CDNS_406619531457_2/a_1952_n44#
+ nmos_6p0_CDNS_406619531457_2/a_2928_n44# nmos_6p0_CDNS_406619531457_3/a_244_n44#
+ nmos_6p0_CDNS_406619531457_3/a_4392_n44# nmos_6p0_CDNS_406619531457_2/a_3172_n44#
+ nmos_6p0_CDNS_406619531457_2/a_4148_n44# nmos_6p0_CDNS_406619531457_0/a_2196_n44#
+ M2_M1_CDNS_40661953145136_4/m1_n92_n2414# nmos_6p0_CDNS_406619531457_1/a_1708_n44#
+ nmos_6p0_CDNS_406619531457_3/a_488_n44# nmos_6p0_CDNS_406619531457_3/a_1952_n44#
+ nmos_6p0_CDNS_406619531457_3/a_2928_n44# nmos_6p0_CDNS_406619531457_2/a_1708_n44#
+ nmos_6p0_CDNS_406619531457_1/a_2196_n44# nmos_6p0_CDNS_406619531457_3/a_3172_n44#
+ nmos_6p0_CDNS_406619531457_3/a_4148_n44# nmos_6p0_CDNS_406619531457_3/a_1708_n44#
+ nmos_6p0_CDNS_406619531457_2/a_2196_n44# nmos_6p0_CDNS_406619531457_2/a_0_n44# nmos_6p0_CDNS_406619531457_3/a_2196_n44#
+ nmos_6p0_CDNS_406619531457_2/D nmos_6p0_CDNS_406619531457_0/a_732_n44# nmos_6p0_CDNS_406619531457_1/D
+ M2_M1_CDNS_4066195314573_7/m1_n92_n146# nmos_6p0_CDNS_406619531457_0/a_976_n44#
+ M2_M1_CDNS_40661953145136_3/m1_n92_n2414# nmos_6p0_CDNS_406619531457_1/a_732_n44#
+ nmos_6p0_CDNS_406619531457_1/S nmos_6p0_CDNS_406619531457_1/a_976_n44# nmos_6p0_CDNS_406619531457_0/D
+ nmos_6p0_CDNS_406619531457_2/S nmos_6p0_CDNS_406619531457_0/S nmos_6p0_CDNS_406619531457_3/D
+ VSUBS
Xnmos_6p0_CDNS_406619531457_0 nmos_6p0_CDNS_406619531457_0/D nmos_6p0_CDNS_406619531457_0/a_3904_n44#
+ nmos_6p0_CDNS_406619531457_0/a_4392_n44# nmos_6p0_CDNS_406619531457_0/a_2928_n44#
+ nmos_6p0_CDNS_406619531457_0/a_1952_n44# nmos_6p0_CDNS_406619531457_0/a_4148_n44#
+ nmos_6p0_CDNS_406619531457_0/a_3172_n44# nmos_6p0_CDNS_406619531457_0/a_1708_n44#
+ nmos_6p0_CDNS_406619531457_0/a_2196_n44# nmos_6p0_CDNS_406619531457_0/a_732_n44#
+ nmos_6p0_CDNS_406619531457_0/a_976_n44# nmos_6p0_CDNS_406619531457_0/a_0_n44# nmos_6p0_CDNS_406619531457_0/S
+ nmos_6p0_CDNS_406619531457_0/a_4636_n44# nmos_6p0_CDNS_406619531457_0/a_3660_n44#
+ nmos_6p0_CDNS_406619531457_0/a_3416_n44# nmos_6p0_CDNS_406619531457_0/a_2440_n44#
+ nmos_6p0_CDNS_406619531457_0/a_2684_n44# nmos_6p0_CDNS_406619531457_0/a_1220_n44#
+ nmos_6p0_CDNS_406619531457_0/a_1464_n44# nmos_6p0_CDNS_406619531457_0/a_244_n44#
+ nmos_6p0_CDNS_406619531457_0/a_488_n44# VSUBS nmos_6p0_CDNS_406619531457
Xnmos_6p0_CDNS_406619531457_1 nmos_6p0_CDNS_406619531457_1/D nmos_6p0_CDNS_406619531457_1/a_3904_n44#
+ nmos_6p0_CDNS_406619531457_1/a_4392_n44# nmos_6p0_CDNS_406619531457_1/a_2928_n44#
+ nmos_6p0_CDNS_406619531457_1/a_1952_n44# nmos_6p0_CDNS_406619531457_1/a_4148_n44#
+ nmos_6p0_CDNS_406619531457_1/a_3172_n44# nmos_6p0_CDNS_406619531457_1/a_1708_n44#
+ nmos_6p0_CDNS_406619531457_1/a_2196_n44# nmos_6p0_CDNS_406619531457_1/a_732_n44#
+ nmos_6p0_CDNS_406619531457_1/a_976_n44# nmos_6p0_CDNS_406619531457_1/a_0_n44# nmos_6p0_CDNS_406619531457_1/S
+ nmos_6p0_CDNS_406619531457_1/a_4636_n44# nmos_6p0_CDNS_406619531457_1/a_3660_n44#
+ nmos_6p0_CDNS_406619531457_1/a_3416_n44# nmos_6p0_CDNS_406619531457_1/a_2440_n44#
+ nmos_6p0_CDNS_406619531457_1/a_2684_n44# nmos_6p0_CDNS_406619531457_1/a_1220_n44#
+ nmos_6p0_CDNS_406619531457_1/a_1464_n44# nmos_6p0_CDNS_406619531457_1/a_244_n44#
+ nmos_6p0_CDNS_406619531457_1/a_488_n44# VSUBS nmos_6p0_CDNS_406619531457
Xnmos_6p0_CDNS_406619531457_2 nmos_6p0_CDNS_406619531457_2/D nmos_6p0_CDNS_406619531457_2/a_3904_n44#
+ nmos_6p0_CDNS_406619531457_2/a_4392_n44# nmos_6p0_CDNS_406619531457_2/a_2928_n44#
+ nmos_6p0_CDNS_406619531457_2/a_1952_n44# nmos_6p0_CDNS_406619531457_2/a_4148_n44#
+ nmos_6p0_CDNS_406619531457_2/a_3172_n44# nmos_6p0_CDNS_406619531457_2/a_1708_n44#
+ nmos_6p0_CDNS_406619531457_2/a_2196_n44# nmos_6p0_CDNS_406619531457_2/a_732_n44#
+ nmos_6p0_CDNS_406619531457_2/a_976_n44# nmos_6p0_CDNS_406619531457_2/a_0_n44# nmos_6p0_CDNS_406619531457_2/S
+ nmos_6p0_CDNS_406619531457_2/a_4636_n44# nmos_6p0_CDNS_406619531457_2/a_3660_n44#
+ nmos_6p0_CDNS_406619531457_2/a_3416_n44# nmos_6p0_CDNS_406619531457_2/a_2440_n44#
+ nmos_6p0_CDNS_406619531457_2/a_2684_n44# nmos_6p0_CDNS_406619531457_2/a_1220_n44#
+ nmos_6p0_CDNS_406619531457_2/a_1464_n44# nmos_6p0_CDNS_406619531457_2/a_244_n44#
+ nmos_6p0_CDNS_406619531457_2/a_488_n44# VSUBS nmos_6p0_CDNS_406619531457
Xnmos_6p0_CDNS_406619531457_3 nmos_6p0_CDNS_406619531457_3/D nmos_6p0_CDNS_406619531457_3/a_3904_n44#
+ nmos_6p0_CDNS_406619531457_3/a_4392_n44# nmos_6p0_CDNS_406619531457_3/a_2928_n44#
+ nmos_6p0_CDNS_406619531457_3/a_1952_n44# nmos_6p0_CDNS_406619531457_3/a_4148_n44#
+ nmos_6p0_CDNS_406619531457_3/a_3172_n44# nmos_6p0_CDNS_406619531457_3/a_1708_n44#
+ nmos_6p0_CDNS_406619531457_3/a_2196_n44# nmos_6p0_CDNS_406619531457_3/a_732_n44#
+ nmos_6p0_CDNS_406619531457_3/a_976_n44# nmos_6p0_CDNS_406619531457_3/a_0_n44# nmos_6p0_CDNS_406619531457_3/S
+ nmos_6p0_CDNS_406619531457_3/a_4636_n44# nmos_6p0_CDNS_406619531457_3/a_3660_n44#
+ nmos_6p0_CDNS_406619531457_3/a_3416_n44# nmos_6p0_CDNS_406619531457_3/a_2440_n44#
+ nmos_6p0_CDNS_406619531457_3/a_2684_n44# nmos_6p0_CDNS_406619531457_3/a_1220_n44#
+ nmos_6p0_CDNS_406619531457_3/a_1464_n44# nmos_6p0_CDNS_406619531457_3/a_244_n44#
+ nmos_6p0_CDNS_406619531457_3/a_488_n44# VSUBS nmos_6p0_CDNS_406619531457
.ends

.subckt nmos_6p0_CDNS_406619531458 D a_732_n44# a_976_n44# a_0_n44# S a_1220_n44#
+ a_244_n44# a_488_n44# VSUBS
X0 D a_976_n44# S VSUBS nfet_05v0 ad=1.3p pd=5.52u as=1.3p ps=5.52u w=5u l=0.7u
X1 S a_732_n44# D VSUBS nfet_05v0 ad=1.3p pd=5.52u as=1.3p ps=5.52u w=5u l=0.7u
X2 S a_1220_n44# D VSUBS nfet_05v0 ad=2.2p pd=10.88u as=1.3p ps=5.52u w=5u l=0.7u
X3 S a_244_n44# D VSUBS nfet_05v0 ad=1.3p pd=5.52u as=1.3p ps=5.52u w=5u l=0.7u
X4 D a_488_n44# S VSUBS nfet_05v0 ad=1.3p pd=5.52u as=1.3p ps=5.52u w=5u l=0.7u
X5 D a_0_n44# S VSUBS nfet_05v0 ad=1.3p pd=5.52u as=2.2p ps=10.88u w=5u l=0.7u
.ends

.subckt comp018green_esd_clamp_v5p0_DVSS pmos_6p0_CDNS_406619531452_0/a_244_n44# pmos_6p0_CDNS_406619531452_0/D
+ pmos_6p0_CDNS_406619531452_0/a_488_n44# comp018green_esd_rc_v5p0_0/ppolyf_u_CDNS_406619531453_8/PLUS
+ nmos_clamp_20_50_4_DVSS_0/nmos_6p0_CDNS_406619531457_0/a_732_n44# nmos_clamp_20_50_4_DVSS_0/nmos_6p0_CDNS_406619531457_0/a_976_n44#
+ nmos_clamp_20_50_4_DVSS_0/nmos_6p0_CDNS_406619531457_1/a_0_n44# M1_POLY2_CDNS_40661953145106_0/a_n89_n42#
+ nmos_clamp_20_50_4_DVSS_0/nmos_6p0_CDNS_406619531457_0/a_3904_n44# comp018green_esd_rc_v5p0_0/ppolyf_u_CDNS_406619531453_10/PLUS
+ comp018green_esd_rc_v5p0_0/ppolyf_u_CDNS_406619531453_5/PLUS nmos_clamp_20_50_4_DVSS_0/nmos_6p0_CDNS_406619531457_1/a_3904_n44#
+ nmos_clamp_20_50_4_DVSS_0/M2_M1_CDNS_40661953145136_7/m1_n92_n2414# nmos_clamp_20_50_4_DVSS_0/nmos_6p0_CDNS_406619531457_0/a_4392_n44#
+ nmos_clamp_20_50_4_DVSS_0/nmos_6p0_CDNS_406619531457_1/a_732_n44# nmos_clamp_20_50_4_DVSS_0/M2_M1_CDNS_40661953145136_2/m1_n92_n2414#
+ nmos_clamp_20_50_4_DVSS_0/nmos_6p0_CDNS_406619531457_2/a_3904_n44# nmos_clamp_20_50_4_DVSS_0/nmos_6p0_CDNS_406619531457_0/a_2928_n44#
+ nmos_clamp_20_50_4_DVSS_0/nmos_6p0_CDNS_406619531457_0/a_1952_n44# nmos_clamp_20_50_4_DVSS_0/nmos_6p0_CDNS_406619531457_1/a_976_n44#
+ nmos_clamp_20_50_4_DVSS_0/nmos_6p0_CDNS_406619531457_1/a_4392_n44# nmos_clamp_20_50_4_DVSS_0/nmos_6p0_CDNS_406619531457_0/a_4148_n44#
+ nmos_clamp_20_50_4_DVSS_0/nmos_6p0_CDNS_406619531457_0/a_3172_n44# pmos_6p0_CDNS_406619531455_0/a_5612_n44#
+ nmos_clamp_20_50_4_DVSS_0/nmos_6p0_CDNS_406619531457_1/a_1952_n44# nmos_clamp_20_50_4_DVSS_0/nmos_6p0_CDNS_406619531457_1/a_2928_n44#
+ nmos_clamp_20_50_4_DVSS_0/nmos_6p0_CDNS_406619531457_3/a_3904_n44# nmos_6p0_CDNS_406619531458_0/a_244_n44#
+ nmos_6p0_CDNS_406619531459_0/S nmos_clamp_20_50_4_DVSS_0/nmos_6p0_CDNS_406619531457_2/a_4392_n44#
+ nmos_clamp_20_50_4_DVSS_0/nmos_6p0_CDNS_406619531457_0/a_1708_n44# nmos_clamp_20_50_4_DVSS_0/nmos_6p0_CDNS_406619531457_1/a_3172_n44#
+ pmos_6p0_CDNS_406619531456_0/a_244_n44# nmos_clamp_20_50_4_DVSS_0/nmos_6p0_CDNS_406619531457_1/a_4148_n44#
+ nmos_6p0_CDNS_406619531458_0/a_488_n44# pmos_6p0_CDNS_406619531455_0/a_4880_n44#
+ M2_M1_CDNS_4066195314585_1/m1_n254_n38# comp018green_esd_rc_v5p0_0/ppolyf_u_CDNS_406619531453_2/PLUS
+ nmos_clamp_20_50_4_DVSS_0/nmos_6p0_CDNS_406619531457_2/a_1952_n44# nmos_clamp_20_50_4_DVSS_0/nmos_6p0_CDNS_406619531457_2/a_2928_n44#
+ nmos_clamp_20_50_4_DVSS_0/nmos_6p0_CDNS_406619531457_3/a_4392_n44# nmos_clamp_20_50_4_DVSS_0/nmos_6p0_CDNS_406619531457_2/a_3172_n44#
+ nmos_clamp_20_50_4_DVSS_0/nmos_6p0_CDNS_406619531457_2/a_4148_n44# nmos_clamp_20_50_4_DVSS_0/nmos_6p0_CDNS_406619531457_1/a_1708_n44#
+ pmos_6p0_CDNS_406619531456_0/a_488_n44# nmos_clamp_20_50_4_DVSS_0/nmos_6p0_CDNS_406619531457_0/a_2196_n44#
+ nmos_6p0_CDNS_406619531458_0/a_0_n44# pmos_6p0_CDNS_406619531455_0/a_3660_n44# nmos_clamp_20_50_4_DVSS_0/nmos_6p0_CDNS_406619531457_3/a_1952_n44#
+ nmos_clamp_20_50_4_DVSS_0/nmos_6p0_CDNS_406619531457_3/a_2928_n44# pmos_6p0_CDNS_406619531455_0/a_4636_n44#
+ nmos_clamp_20_50_4_DVSS_0/nmos_6p0_CDNS_406619531457_2/a_1708_n44# nmos_clamp_20_50_4_DVSS_0/nmos_6p0_CDNS_406619531457_2/a_732_n44#
+ nmos_clamp_20_50_4_DVSS_0/nmos_6p0_CDNS_406619531457_3/a_3172_n44# nmos_clamp_20_50_4_DVSS_0/nmos_6p0_CDNS_406619531457_3/a_4148_n44#
+ nmos_clamp_20_50_4_DVSS_0/nmos_6p0_CDNS_406619531457_1/a_2196_n44# nmos_clamp_20_50_4_DVSS_0/nmos_6p0_CDNS_406619531457_2/a_976_n44#
+ pmos_6p0_CDNS_406619531456_0/D pmos_6p0_CDNS_406619531455_0/a_2440_n44# pmos_6p0_CDNS_406619531455_0/a_3416_n44#
+ nmos_clamp_20_50_4_DVSS_0/nmos_6p0_CDNS_406619531457_3/a_1708_n44# nmos_clamp_20_50_4_DVSS_0/nmos_6p0_CDNS_406619531457_2/a_2196_n44#
+ nmos_6p0_CDNS_406619531458_1/a_244_n44# pmos_6p0_CDNS_406619531455_0/a_0_n44# M1_POLY2_CDNS_40661953145110_0/a_n2862_n42#
+ pmos_6p0_CDNS_406619531455_0/a_2684_n44# pmos_6p0_CDNS_406619531455_0/a_1220_n44#
+ nmos_6p0_CDNS_406619531458_1/a_488_n44# nmos_clamp_20_50_4_DVSS_0/nmos_6p0_CDNS_406619531457_3/a_2196_n44#
+ nmos_6p0_CDNS_406619531458_0/D nmos_6p0_CDNS_406619531459_0/a_0_n44# pmos_6p0_CDNS_406619531455_0/a_1464_n44#
+ M1_POLY2_CDNS_40661953145109_0/a_n653_n42# nmos_clamp_20_50_4_DVSS_0/nmos_6p0_CDNS_406619531457_3/S
+ nmos_clamp_20_50_4_DVSS_0/nmos_6p0_CDNS_406619531457_3/a_732_n44# M1_POLY2_CDNS_40661953145109_1/a_n653_n42#
+ nmos_clamp_20_50_4_DVSS_0/M2_M1_CDNS_40661953145136_6/m1_n92_n2414# nmos_clamp_20_50_4_DVSS_0/nmos_6p0_CDNS_406619531457_3/a_976_n44#
+ nmos_clamp_20_50_4_DVSS_0/M2_M1_CDNS_40661953145136_1/m1_n92_n2414# pmos_6p0_CDNS_406619531456_0/a_0_n44#
+ comp018green_esd_rc_v5p0_0/ppolyf_u_CDNS_406619531453_9/PLUS nmos_clamp_20_50_4_DVSS_0/nmos_6p0_CDNS_406619531457_2/a_0_n44#
+ pmos_6p0_CDNS_406619531455_0/a_244_n44# pmos_6p0_CDNS_406619531455_0/a_488_n44#
+ comp018green_esd_rc_v5p0_0/ppolyf_u_CDNS_406619531453_11/PLUS comp018green_esd_rc_v5p0_0/ppolyf_u_CDNS_406619531453_6/PLUS
+ M2_M1_CDNS_40661953145159_1/m1_n714_n38# comp018green_esd_rc_v5p0_0/ppolyf_u_CDNS_406619531453_0/MINUS
+ pmos_6p0_CDNS_406619531452_0/a_732_n44# comp018green_esd_rc_v5p0_0/ppolyf_u_CDNS_406619531453_1/MINUS
+ nmos_6p0_CDNS_406619531458_0/a_1220_n44# M2_M1_CDNS_40661953145113_0/m1_n454_n38#
+ comp018green_esd_rc_v5p0_0/ppolyf_u_CDNS_406619531453_3/PLUS nmos_6p0_CDNS_406619531458_1/a_0_n44#
+ M2_M1_CDNS_40661953145125_1/m1_n142_n38# comp018green_esd_rc_v5p0_0/ppolyf_u_CDNS_406619531453_2/MINUS
+ nmos_6p0_CDNS_406619531458_1/a_1220_n44# pmos_6p0_CDNS_406619531455_0/S nmos_clamp_20_50_4_DVSS_0/M2_M1_CDNS_40661953145136_5/m1_n92_n2414#
+ comp018green_esd_rc_v5p0_0/ppolyf_u_CDNS_406619531453_3/MINUS nmos_clamp_20_50_4_DVSS_0/M2_M1_CDNS_40661953145136_0/m1_n92_n2414#
+ comp018green_esd_rc_v5p0_0/ppolyf_u_CDNS_406619531453_0/PLUS nmos_6p0_CDNS_406619531459_0/D
+ nmos_clamp_20_50_4_DVSS_0/nmos_6p0_CDNS_406619531457_0/a_244_n44# comp018green_esd_rc_v5p0_0/ppolyf_u_CDNS_406619531453_4/MINUS
+ comp018green_esd_rc_v5p0_0/ppolyf_u_CDNS_406619531453_10/MINUS nmos_clamp_20_50_4_DVSS_0/nmos_6p0_CDNS_406619531457_0/a_488_n44#
+ comp018green_esd_rc_v5p0_0/ppolyf_u_CDNS_406619531453_5/MINUS nmos_clamp_20_50_4_DVSS_0/nmos_6p0_CDNS_406619531457_0/a_3660_n44#
+ nmos_clamp_20_50_4_DVSS_0/nmos_6p0_CDNS_406619531457_0/a_4636_n44# nmos_6p0_CDNS_406619531458_0/a_732_n44#
+ comp018green_esd_rc_v5p0_0/ppolyf_u_CDNS_406619531453_11/MINUS nmos_clamp_20_50_4_DVSS_0/nmos_6p0_CDNS_406619531457_1/a_3660_n44#
+ nmos_clamp_20_50_4_DVSS_0/nmos_6p0_CDNS_406619531457_1/a_4636_n44# M2_M1_CDNS_40661953145159_0/m1_n714_n38#
+ nmos_clamp_20_50_4_DVSS_0/nmos_6p0_CDNS_406619531457_0/a_2440_n44# nmos_clamp_20_50_4_DVSS_0/nmos_6p0_CDNS_406619531457_0/a_3416_n44#
+ nmos_6p0_CDNS_406619531458_0/a_976_n44# comp018green_esd_rc_v5p0_0/ppolyf_u_CDNS_406619531453_6/MINUS
+ nmos_clamp_20_50_4_DVSS_0/nmos_6p0_CDNS_406619531457_2/a_4636_n44# nmos_clamp_20_50_4_DVSS_0/nmos_6p0_CDNS_406619531457_2/a_3660_n44#
+ nmos_clamp_20_50_4_DVSS_0/nmos_6p0_CDNS_406619531457_0/a_2684_n44# nmos_clamp_20_50_4_DVSS_0/nmos_6p0_CDNS_406619531457_3/a_0_n44#
+ nmos_clamp_20_50_4_DVSS_0/nmos_6p0_CDNS_406619531457_1/a_2440_n44# nmos_clamp_20_50_4_DVSS_0/nmos_6p0_CDNS_406619531457_1/a_3416_n44#
+ nmos_clamp_20_50_4_DVSS_0/nmos_6p0_CDNS_406619531457_0/a_1220_n44# nmos_clamp_20_50_4_DVSS_0/nmos_6p0_CDNS_406619531457_1/a_244_n44#
+ comp018green_esd_rc_v5p0_0/ppolyf_u_CDNS_406619531453_7/MINUS nmos_clamp_20_50_4_DVSS_0/nmos_6p0_CDNS_406619531457_2/a_2440_n44#
+ nmos_clamp_20_50_4_DVSS_0/nmos_6p0_CDNS_406619531457_1/a_2684_n44# nmos_clamp_20_50_4_DVSS_0/nmos_6p0_CDNS_406619531457_3/a_3660_n44#
+ nmos_clamp_20_50_4_DVSS_0/nmos_6p0_CDNS_406619531457_3/a_4636_n44# nmos_clamp_20_50_4_DVSS_0/nmos_6p0_CDNS_406619531457_1/S
+ nmos_clamp_20_50_4_DVSS_0/nmos_6p0_CDNS_406619531457_2/a_3416_n44# nmos_clamp_20_50_4_DVSS_0/nmos_6p0_CDNS_406619531457_0/a_1464_n44#
+ nmos_clamp_20_50_4_DVSS_0/nmos_6p0_CDNS_406619531457_1/a_1220_n44# nmos_clamp_20_50_4_DVSS_0/nmos_6p0_CDNS_406619531457_1/a_488_n44#
+ pmos_6p0_CDNS_406619531455_0/a_3904_n44# nmos_clamp_20_50_4_DVSS_0/nmos_6p0_CDNS_406619531457_2/a_2684_n44#
+ nmos_clamp_20_50_4_DVSS_0/nmos_6p0_CDNS_406619531457_3/a_2440_n44# nmos_clamp_20_50_4_DVSS_0/nmos_6p0_CDNS_406619531457_3/a_3416_n44#
+ pmos_6p0_CDNS_406619531455_0/a_5124_n44# M2_M1_CDNS_40661953145125_0/m1_n142_n38#
+ nmos_6p0_CDNS_406619531458_1/a_732_n44# nmos_clamp_20_50_4_DVSS_0/nmos_6p0_CDNS_406619531457_2/a_1220_n44#
+ nmos_clamp_20_50_4_DVSS_0/nmos_6p0_CDNS_406619531457_1/a_1464_n44# M2_M1_CDNS_4066195314586_1/m1_n92_n38#
+ comp018green_esd_rc_v5p0_0/ppolyf_u_CDNS_406619531453_8/MINUS pmos_6p0_CDNS_406619531455_0/a_4392_n44#
+ pmos_6p0_CDNS_406619531455_0/a_5368_n44# nmos_6p0_CDNS_406619531458_1/a_976_n44#
+ nmos_clamp_20_50_4_DVSS_0/M2_M1_CDNS_40661953145136_4/m1_n92_n2414# nmos_clamp_20_50_4_DVSS_0/nmos_6p0_CDNS_406619531457_3/a_2684_n44#
+ comp018green_esd_rc_v5p0_0/ppolyf_u_CDNS_406619531453_7/PLUS nmos_clamp_20_50_4_DVSS_0/nmos_6p0_CDNS_406619531457_2/a_1464_n44#
+ nmos_clamp_20_50_4_DVSS_0/nmos_6p0_CDNS_406619531457_3/a_1220_n44# pmos_6p0_CDNS_406619531455_0/a_2928_n44#
+ pmos_6p0_CDNS_406619531455_0/a_1952_n44# pmos_6p0_CDNS_406619531455_0/a_3172_n44#
+ pmos_6p0_CDNS_406619531455_0/a_4148_n44# comp018green_esd_rc_v5p0_0/ppolyf_u_CDNS_406619531453_9/MINUS
+ nmos_clamp_20_50_4_DVSS_0/nmos_6p0_CDNS_406619531457_0/a_0_n44# nmos_clamp_20_50_4_DVSS_0/nmos_6p0_CDNS_406619531457_3/a_1464_n44#
+ M2_M1_CDNS_4066195314586_3/m1_n92_n38# nmos_clamp_20_50_4_DVSS_0/nmos_6p0_CDNS_406619531457_2/a_244_n44#
+ pmos_6p0_CDNS_406619531455_0/a_1708_n44# nmos_clamp_20_50_4_DVSS_0/nmos_6p0_CDNS_406619531457_2/a_488_n44#
+ M2_M1_CDNS_4066195314586_4/m1_n92_n38# comp018green_esd_rc_v5p0_0/ppolyf_u_CDNS_406619531453_4/PLUS
+ M1_POLY2_CDNS_40661953145105_0/a_n371_n42# pmos_6p0_CDNS_406619531455_0/a_2196_n44#
+ nmos_6p0_CDNS_406619531458_1/D pmos_6p0_CDNS_406619531456_0/S M2_M1_CDNS_4066195314586_6/m1_n92_n38#
+ pmos_6p0_CDNS_406619531455_0/a_732_n44# M2_M1_CDNS_4066195314586_7/m1_n92_n38# nmos_clamp_20_50_4_DVSS_0/nmos_6p0_CDNS_406619531457_3/a_244_n44#
+ M2_M1_CDNS_40661953145103_0/m1_n92_n92# nmos_6p0_CDNS_406619531458_1/S pmos_6p0_CDNS_406619531455_0/a_976_n44#
+ nmos_clamp_20_50_4_DVSS_0/nmos_6p0_CDNS_406619531457_3/a_488_n44# M2_M1_CDNS_40661953145103_1/m1_n92_n92#
+ comp018green_esd_rc_v5p0_0/ppolyf_u_CDNS_406619531453_1/PLUS M2_M1_CDNS_40661953145117_2/m1_n90_n38#
+ nmos_clamp_20_50_4_DVSS_0/M2_M1_CDNS_40661953145136_3/m1_n92_n2414# pmos_6p0_CDNS_406619531455_0/D
+ M1_POLY2_CDNS_40661953145108_0/a_n277_n42# M2_M1_CDNS_40661953145117_3/m1_n90_n38#
+ M2_M1_CDNS_40661953145117_1/m1_n90_n38# nmos_clamp_20_50_4_DVSS_0/nmos_6p0_CDNS_406619531457_3/D
+ nmos_clamp_20_50_4_DVSS_0/nmos_6p0_CDNS_406619531457_2/D nmos_clamp_20_50_4_DVSS_0/nmos_6p0_CDNS_406619531457_0/D
+ VSUBS nmos_clamp_20_50_4_DVSS_0/M2_M1_CDNS_4066195314573_7/m1_n92_n146# nmos_clamp_20_50_4_DVSS_0/nmos_6p0_CDNS_406619531457_1/D
+ nmos_clamp_20_50_4_DVSS_0/nmos_6p0_CDNS_406619531457_2/S nmos_clamp_20_50_4_DVSS_0/nmos_6p0_CDNS_406619531457_0/S
+ pmos_6p0_CDNS_406619531452_0/a_0_n44# M2_M1_CDNS_40661953145118_0/m1_n974_n38#
Xpmos_6p0_CDNS_406619531455_0 M2_M1_CDNS_40661953145117_1/m1_n90_n38# pmos_6p0_CDNS_406619531455_0/D
+ pmos_6p0_CDNS_406619531455_0/a_5124_n44# pmos_6p0_CDNS_406619531455_0/a_3904_n44#
+ pmos_6p0_CDNS_406619531455_0/a_5368_n44# pmos_6p0_CDNS_406619531455_0/a_4392_n44#
+ pmos_6p0_CDNS_406619531455_0/a_2928_n44# pmos_6p0_CDNS_406619531455_0/a_1952_n44#
+ pmos_6p0_CDNS_406619531455_0/a_4148_n44# pmos_6p0_CDNS_406619531455_0/a_3172_n44#
+ pmos_6p0_CDNS_406619531455_0/a_1708_n44# pmos_6p0_CDNS_406619531455_0/a_2196_n44#
+ pmos_6p0_CDNS_406619531455_0/a_732_n44# pmos_6p0_CDNS_406619531455_0/a_976_n44#
+ pmos_6p0_CDNS_406619531455_0/a_0_n44# pmos_6p0_CDNS_406619531455_0/a_5612_n44# pmos_6p0_CDNS_406619531455_0/a_4880_n44#
+ pmos_6p0_CDNS_406619531455_0/S pmos_6p0_CDNS_406619531455_0/a_4636_n44# pmos_6p0_CDNS_406619531455_0/a_3660_n44#
+ pmos_6p0_CDNS_406619531455_0/a_3416_n44# pmos_6p0_CDNS_406619531455_0/a_2440_n44#
+ pmos_6p0_CDNS_406619531455_0/a_2684_n44# pmos_6p0_CDNS_406619531455_0/a_1220_n44#
+ pmos_6p0_CDNS_406619531455_0/a_1464_n44# pmos_6p0_CDNS_406619531455_0/a_244_n44#
+ pmos_6p0_CDNS_406619531455_0/a_488_n44# pmos_6p0_CDNS_406619531455
Xnmos_6p0_CDNS_406619531459_0 nmos_6p0_CDNS_406619531459_0/D nmos_6p0_CDNS_406619531459_0/a_0_n44#
+ nmos_6p0_CDNS_406619531459_0/S VSUBS nmos_6p0_CDNS_406619531459
Xpmos_6p0_CDNS_406619531456_0 M2_M1_CDNS_40661953145117_1/m1_n90_n38# pmos_6p0_CDNS_406619531456_0/D
+ pmos_6p0_CDNS_406619531456_0/a_0_n44# pmos_6p0_CDNS_406619531456_0/S pmos_6p0_CDNS_406619531456_0/a_244_n44#
+ pmos_6p0_CDNS_406619531456_0/a_488_n44# pmos_6p0_CDNS_406619531456
Xcomp018green_esd_rc_v5p0_0 comp018green_esd_rc_v5p0_0/ppolyf_u_CDNS_406619531453_10/MINUS
+ comp018green_esd_rc_v5p0_0/ppolyf_u_CDNS_406619531453_3/PLUS comp018green_esd_rc_v5p0_0/ppolyf_u_CDNS_406619531453_11/MINUS
+ comp018green_esd_rc_v5p0_0/ppolyf_u_CDNS_406619531453_0/PLUS comp018green_esd_rc_v5p0_0/ppolyf_u_CDNS_406619531453_11/PLUS
+ comp018green_esd_rc_v5p0_0/ppolyf_u_CDNS_406619531453_0/MINUS comp018green_esd_rc_v5p0_0/ppolyf_u_CDNS_406619531453_7/PLUS
+ comp018green_esd_rc_v5p0_0/ppolyf_u_CDNS_406619531453_1/MINUS comp018green_esd_rc_v5p0_0/ppolyf_u_CDNS_406619531453_2/MINUS
+ comp018green_esd_rc_v5p0_0/ppolyf_u_CDNS_406619531453_3/MINUS comp018green_esd_rc_v5p0_0/ppolyf_u_CDNS_406619531453_4/PLUS
+ comp018green_esd_rc_v5p0_0/ppolyf_u_CDNS_406619531453_4/MINUS comp018green_esd_rc_v5p0_0/ppolyf_u_CDNS_406619531453_5/MINUS
+ M2_M1_CDNS_4066195314586_6/m1_n92_n38# comp018green_esd_rc_v5p0_0/ppolyf_u_CDNS_406619531453_1/PLUS
+ comp018green_esd_rc_v5p0_0/ppolyf_u_CDNS_406619531453_6/MINUS comp018green_esd_rc_v5p0_0/ppolyf_u_CDNS_406619531453_7/MINUS
+ comp018green_esd_rc_v5p0_0/ppolyf_u_CDNS_406619531453_8/MINUS comp018green_esd_rc_v5p0_0/ppolyf_u_CDNS_406619531453_9/MINUS
+ comp018green_esd_rc_v5p0_0/ppolyf_u_CDNS_406619531453_8/PLUS comp018green_esd_rc_v5p0_0/ppolyf_u_CDNS_406619531453_5/PLUS
+ comp018green_esd_rc_v5p0_0/ppolyf_u_CDNS_406619531453_2/PLUS comp018green_esd_rc_v5p0_0/ppolyf_u_CDNS_406619531453_10/PLUS
+ comp018green_esd_rc_v5p0_0/ppolyf_u_CDNS_406619531453_9/PLUS comp018green_esd_rc_v5p0_0/ppolyf_u_CDNS_406619531453_6/PLUS
+ VSUBS comp018green_esd_rc_v5p0
Xpmos_6p0_CDNS_406619531452_0 M2_M1_CDNS_40661953145117_1/m1_n90_n38# pmos_6p0_CDNS_406619531452_0/D
+ pmos_6p0_CDNS_406619531452_0/a_732_n44# pmos_6p0_CDNS_406619531452_0/a_0_n44# pmos_6p0_CDNS_406619531456_0/S
+ pmos_6p0_CDNS_406619531452_0/a_244_n44# pmos_6p0_CDNS_406619531452_0/a_488_n44#
+ pmos_6p0_CDNS_406619531452
Xnmos_clamp_20_50_4_DVSS_0 nmos_clamp_20_50_4_DVSS_0/nmos_6p0_CDNS_406619531457_2/a_732_n44#
+ nmos_clamp_20_50_4_DVSS_0/nmos_6p0_CDNS_406619531457_3/a_0_n44# nmos_clamp_20_50_4_DVSS_0/nmos_6p0_CDNS_406619531457_2/a_976_n44#
+ nmos_clamp_20_50_4_DVSS_0/M2_M1_CDNS_40661953145136_7/m1_n92_n2414# nmos_clamp_20_50_4_DVSS_0/M2_M1_CDNS_40661953145136_2/m1_n92_n2414#
+ nmos_clamp_20_50_4_DVSS_0/nmos_6p0_CDNS_406619531457_0/a_3660_n44# nmos_clamp_20_50_4_DVSS_0/nmos_6p0_CDNS_406619531457_0/a_4636_n44#
+ nmos_clamp_20_50_4_DVSS_0/nmos_6p0_CDNS_406619531457_1/a_3660_n44# nmos_clamp_20_50_4_DVSS_0/nmos_6p0_CDNS_406619531457_1/a_4636_n44#
+ nmos_clamp_20_50_4_DVSS_0/nmos_6p0_CDNS_406619531457_0/a_2440_n44# nmos_clamp_20_50_4_DVSS_0/nmos_6p0_CDNS_406619531457_0/a_3416_n44#
+ nmos_clamp_20_50_4_DVSS_0/nmos_6p0_CDNS_406619531457_3/a_732_n44# nmos_clamp_20_50_4_DVSS_0/nmos_6p0_CDNS_406619531457_2/a_4636_n44#
+ nmos_clamp_20_50_4_DVSS_0/nmos_6p0_CDNS_406619531457_2/a_3660_n44# nmos_clamp_20_50_4_DVSS_0/nmos_6p0_CDNS_406619531457_0/a_0_n44#
+ nmos_clamp_20_50_4_DVSS_0/nmos_6p0_CDNS_406619531457_0/a_2684_n44# nmos_clamp_20_50_4_DVSS_0/nmos_6p0_CDNS_406619531457_1/a_2440_n44#
+ nmos_clamp_20_50_4_DVSS_0/nmos_6p0_CDNS_406619531457_1/a_3416_n44# nmos_clamp_20_50_4_DVSS_0/nmos_6p0_CDNS_406619531457_0/a_1220_n44#
+ nmos_clamp_20_50_4_DVSS_0/nmos_6p0_CDNS_406619531457_3/a_976_n44# nmos_clamp_20_50_4_DVSS_0/nmos_6p0_CDNS_406619531457_3/a_3660_n44#
+ nmos_clamp_20_50_4_DVSS_0/nmos_6p0_CDNS_406619531457_3/a_4636_n44# nmos_clamp_20_50_4_DVSS_0/nmos_6p0_CDNS_406619531457_2/a_3416_n44#
+ nmos_clamp_20_50_4_DVSS_0/nmos_6p0_CDNS_406619531457_2/a_2440_n44# nmos_clamp_20_50_4_DVSS_0/nmos_6p0_CDNS_406619531457_1/a_2684_n44#
+ nmos_clamp_20_50_4_DVSS_0/nmos_6p0_CDNS_406619531457_0/a_1464_n44# nmos_clamp_20_50_4_DVSS_0/nmos_6p0_CDNS_406619531457_1/a_1220_n44#
+ nmos_clamp_20_50_4_DVSS_0/nmos_6p0_CDNS_406619531457_2/a_2684_n44# nmos_clamp_20_50_4_DVSS_0/nmos_6p0_CDNS_406619531457_1/a_1464_n44#
+ nmos_clamp_20_50_4_DVSS_0/nmos_6p0_CDNS_406619531457_3/a_2440_n44# nmos_clamp_20_50_4_DVSS_0/nmos_6p0_CDNS_406619531457_3/a_3416_n44#
+ nmos_clamp_20_50_4_DVSS_0/nmos_6p0_CDNS_406619531457_2/a_1220_n44# nmos_clamp_20_50_4_DVSS_0/nmos_6p0_CDNS_406619531457_3/a_2684_n44#
+ nmos_clamp_20_50_4_DVSS_0/nmos_6p0_CDNS_406619531457_2/a_1464_n44# nmos_clamp_20_50_4_DVSS_0/nmos_6p0_CDNS_406619531457_3/S
+ nmos_clamp_20_50_4_DVSS_0/nmos_6p0_CDNS_406619531457_3/a_1220_n44# nmos_clamp_20_50_4_DVSS_0/nmos_6p0_CDNS_406619531457_3/a_1464_n44#
+ nmos_clamp_20_50_4_DVSS_0/M2_M1_CDNS_40661953145136_6/m1_n92_n2414# nmos_clamp_20_50_4_DVSS_0/M2_M1_CDNS_40661953145136_1/m1_n92_n2414#
+ nmos_clamp_20_50_4_DVSS_0/nmos_6p0_CDNS_406619531457_0/a_244_n44# nmos_clamp_20_50_4_DVSS_0/nmos_6p0_CDNS_406619531457_0/a_488_n44#
+ nmos_clamp_20_50_4_DVSS_0/nmos_6p0_CDNS_406619531457_1/a_0_n44# nmos_clamp_20_50_4_DVSS_0/M2_M1_CDNS_40661953145136_5/m1_n92_n2414#
+ nmos_clamp_20_50_4_DVSS_0/M2_M1_CDNS_40661953145136_0/m1_n92_n2414# nmos_clamp_20_50_4_DVSS_0/nmos_6p0_CDNS_406619531457_1/a_244_n44#
+ nmos_clamp_20_50_4_DVSS_0/nmos_6p0_CDNS_406619531457_1/a_488_n44# nmos_clamp_20_50_4_DVSS_0/nmos_6p0_CDNS_406619531457_2/a_244_n44#
+ nmos_clamp_20_50_4_DVSS_0/nmos_6p0_CDNS_406619531457_0/a_3904_n44# nmos_clamp_20_50_4_DVSS_0/nmos_6p0_CDNS_406619531457_1/a_3904_n44#
+ nmos_clamp_20_50_4_DVSS_0/nmos_6p0_CDNS_406619531457_2/a_488_n44# nmos_clamp_20_50_4_DVSS_0/nmos_6p0_CDNS_406619531457_0/a_4392_n44#
+ nmos_clamp_20_50_4_DVSS_0/nmos_6p0_CDNS_406619531457_2/a_3904_n44# nmos_clamp_20_50_4_DVSS_0/nmos_6p0_CDNS_406619531457_0/a_2928_n44#
+ nmos_clamp_20_50_4_DVSS_0/nmos_6p0_CDNS_406619531457_0/a_1952_n44# nmos_clamp_20_50_4_DVSS_0/nmos_6p0_CDNS_406619531457_1/a_4392_n44#
+ nmos_clamp_20_50_4_DVSS_0/nmos_6p0_CDNS_406619531457_0/a_4148_n44# nmos_clamp_20_50_4_DVSS_0/nmos_6p0_CDNS_406619531457_0/a_3172_n44#
+ nmos_clamp_20_50_4_DVSS_0/nmos_6p0_CDNS_406619531457_3/a_3904_n44# nmos_clamp_20_50_4_DVSS_0/nmos_6p0_CDNS_406619531457_2/a_4392_n44#
+ nmos_clamp_20_50_4_DVSS_0/nmos_6p0_CDNS_406619531457_1/a_1952_n44# nmos_clamp_20_50_4_DVSS_0/nmos_6p0_CDNS_406619531457_1/a_2928_n44#
+ nmos_clamp_20_50_4_DVSS_0/nmos_6p0_CDNS_406619531457_0/a_1708_n44# nmos_clamp_20_50_4_DVSS_0/nmos_6p0_CDNS_406619531457_1/a_4148_n44#
+ nmos_clamp_20_50_4_DVSS_0/nmos_6p0_CDNS_406619531457_1/a_3172_n44# nmos_clamp_20_50_4_DVSS_0/nmos_6p0_CDNS_406619531457_2/a_1952_n44#
+ nmos_clamp_20_50_4_DVSS_0/nmos_6p0_CDNS_406619531457_2/a_2928_n44# nmos_clamp_20_50_4_DVSS_0/nmos_6p0_CDNS_406619531457_3/a_244_n44#
+ nmos_clamp_20_50_4_DVSS_0/nmos_6p0_CDNS_406619531457_3/a_4392_n44# nmos_clamp_20_50_4_DVSS_0/nmos_6p0_CDNS_406619531457_2/a_3172_n44#
+ nmos_clamp_20_50_4_DVSS_0/nmos_6p0_CDNS_406619531457_2/a_4148_n44# nmos_clamp_20_50_4_DVSS_0/nmos_6p0_CDNS_406619531457_0/a_2196_n44#
+ nmos_clamp_20_50_4_DVSS_0/M2_M1_CDNS_40661953145136_4/m1_n92_n2414# nmos_clamp_20_50_4_DVSS_0/nmos_6p0_CDNS_406619531457_1/a_1708_n44#
+ nmos_clamp_20_50_4_DVSS_0/nmos_6p0_CDNS_406619531457_3/a_488_n44# nmos_clamp_20_50_4_DVSS_0/nmos_6p0_CDNS_406619531457_3/a_1952_n44#
+ nmos_clamp_20_50_4_DVSS_0/nmos_6p0_CDNS_406619531457_3/a_2928_n44# nmos_clamp_20_50_4_DVSS_0/nmos_6p0_CDNS_406619531457_2/a_1708_n44#
+ nmos_clamp_20_50_4_DVSS_0/nmos_6p0_CDNS_406619531457_1/a_2196_n44# nmos_clamp_20_50_4_DVSS_0/nmos_6p0_CDNS_406619531457_3/a_3172_n44#
+ nmos_clamp_20_50_4_DVSS_0/nmos_6p0_CDNS_406619531457_3/a_4148_n44# nmos_clamp_20_50_4_DVSS_0/nmos_6p0_CDNS_406619531457_3/a_1708_n44#
+ nmos_clamp_20_50_4_DVSS_0/nmos_6p0_CDNS_406619531457_2/a_2196_n44# nmos_clamp_20_50_4_DVSS_0/nmos_6p0_CDNS_406619531457_2/a_0_n44#
+ nmos_clamp_20_50_4_DVSS_0/nmos_6p0_CDNS_406619531457_3/a_2196_n44# nmos_clamp_20_50_4_DVSS_0/nmos_6p0_CDNS_406619531457_2/D
+ nmos_clamp_20_50_4_DVSS_0/nmos_6p0_CDNS_406619531457_0/a_732_n44# nmos_clamp_20_50_4_DVSS_0/nmos_6p0_CDNS_406619531457_1/D
+ nmos_clamp_20_50_4_DVSS_0/M2_M1_CDNS_4066195314573_7/m1_n92_n146# nmos_clamp_20_50_4_DVSS_0/nmos_6p0_CDNS_406619531457_0/a_976_n44#
+ nmos_clamp_20_50_4_DVSS_0/M2_M1_CDNS_40661953145136_3/m1_n92_n2414# nmos_clamp_20_50_4_DVSS_0/nmos_6p0_CDNS_406619531457_1/a_732_n44#
+ nmos_clamp_20_50_4_DVSS_0/nmos_6p0_CDNS_406619531457_1/S nmos_clamp_20_50_4_DVSS_0/nmos_6p0_CDNS_406619531457_1/a_976_n44#
+ nmos_clamp_20_50_4_DVSS_0/nmos_6p0_CDNS_406619531457_0/D nmos_clamp_20_50_4_DVSS_0/nmos_6p0_CDNS_406619531457_2/S
+ nmos_clamp_20_50_4_DVSS_0/nmos_6p0_CDNS_406619531457_0/S nmos_clamp_20_50_4_DVSS_0/nmos_6p0_CDNS_406619531457_3/D
+ VSUBS nmos_clamp_20_50_4_DVSS
Xnmos_6p0_CDNS_406619531458_0 nmos_6p0_CDNS_406619531458_0/D nmos_6p0_CDNS_406619531458_0/a_732_n44#
+ nmos_6p0_CDNS_406619531458_0/a_976_n44# nmos_6p0_CDNS_406619531458_0/a_0_n44# nmos_6p0_CDNS_406619531458_1/S
+ nmos_6p0_CDNS_406619531458_0/a_1220_n44# nmos_6p0_CDNS_406619531458_0/a_244_n44#
+ nmos_6p0_CDNS_406619531458_0/a_488_n44# VSUBS nmos_6p0_CDNS_406619531458
Xnmos_6p0_CDNS_406619531458_1 nmos_6p0_CDNS_406619531458_1/D nmos_6p0_CDNS_406619531458_1/a_732_n44#
+ nmos_6p0_CDNS_406619531458_1/a_976_n44# nmos_6p0_CDNS_406619531458_1/a_0_n44# nmos_6p0_CDNS_406619531458_1/S
+ nmos_6p0_CDNS_406619531458_1/a_1220_n44# nmos_6p0_CDNS_406619531458_1/a_244_n44#
+ nmos_6p0_CDNS_406619531458_1/a_488_n44# VSUBS nmos_6p0_CDNS_406619531458
.ends

.subckt np_6p0_CDNS_406619531451 MINUS VSUBS
D0 VSUBS MINUS diode_nd2ps_06v0 pj=82u area=40p
.ends

.subckt GF_NI_DVSS_BASE M3_M2_CDNS_40661953145153_0/m2_n38_n632# comp018green_esd_clamp_v5p0_DVSS_0/M2_M1_CDNS_40661953145113_0/m1_n454_n38#
+ comp018green_esd_clamp_v5p0_DVSS_0/nmos_6p0_CDNS_406619531458_0/a_1220_n44# M3_M2_CDNS_4066195314592_21/m2_n968_n658#
+ comp018green_esd_clamp_v5p0_DVSS_0/M2_M1_CDNS_40661953145125_1/m1_n142_n38# comp018green_esd_clamp_v5p0_DVSS_0/nmos_clamp_20_50_4_DVSS_0/nmos_6p0_CDNS_406619531457_0/a_3904_n44#
+ comp018green_esd_clamp_v5p0_DVSS_0/nmos_6p0_CDNS_406619531458_0/a_244_n44# comp018green_esd_clamp_v5p0_DVSS_0/pmos_6p0_CDNS_406619531452_0/a_0_n44#
+ comp018green_esd_clamp_v5p0_DVSS_0/nmos_6p0_CDNS_406619531458_1/a_1220_n44# M3_M2_CDNS_4066195314587_6/m2_n38_n686#
+ comp018green_esd_clamp_v5p0_DVSS_0/M1_POLY2_CDNS_40661953145110_0/a_n2862_n42# comp018green_esd_clamp_v5p0_DVSS_0/pmos_6p0_CDNS_406619531456_0/D
+ comp018green_esd_clamp_v5p0_DVSS_0/pmos_6p0_CDNS_406619531456_0/a_244_n44# M3_M2_CDNS_4066195314594_5/m2_n100_n658#
+ M3_M2_CDNS_4066195314587_3/m2_n38_n686# M3_M2_CDNS_40661953145152_3/m2_n38_n1496#
+ comp018green_esd_clamp_v5p0_DVSS_0/nmos_6p0_CDNS_406619531458_0/a_488_n44# comp018green_esd_clamp_v5p0_DVSS_0/nmos_clamp_20_50_4_DVSS_0/nmos_6p0_CDNS_406619531457_1/a_3904_n44#
+ comp018green_esd_clamp_v5p0_DVSS_0/nmos_clamp_20_50_4_DVSS_0/nmos_6p0_CDNS_406619531457_0/a_732_n44#
+ comp018green_esd_clamp_v5p0_DVSS_0/M1_POLY2_CDNS_40661953145108_0/a_n277_n42# comp018green_esd_clamp_v5p0_DVSS_0/nmos_clamp_20_50_4_DVSS_0/nmos_6p0_CDNS_406619531457_0/a_4392_n44#
+ M3_M2_CDNS_4066195314594_24/m2_n100_n658# comp018green_esd_clamp_v5p0_DVSS_0/pmos_6p0_CDNS_406619531456_0/a_488_n44#
+ comp018green_esd_clamp_v5p0_DVSS_0/nmos_clamp_20_50_4_DVSS_0/nmos_6p0_CDNS_406619531457_0/a_976_n44#
+ M3_M2_CDNS_4066195314590_5/m2_n906_n658# comp018green_esd_clamp_v5p0_DVSS_0/nmos_6p0_CDNS_406619531458_0/D
+ comp018green_esd_clamp_v5p0_DVSS_0/nmos_clamp_20_50_4_DVSS_0/nmos_6p0_CDNS_406619531457_2/a_3904_n44#
+ M3_M2_CDNS_4066195314589_1/m2_n38_n632# comp018green_esd_clamp_v5p0_DVSS_0/nmos_clamp_20_50_4_DVSS_0/nmos_6p0_CDNS_406619531457_0/a_2928_n44#
+ comp018green_esd_clamp_v5p0_DVSS_0/nmos_clamp_20_50_4_DVSS_0/nmos_6p0_CDNS_406619531457_0/a_1952_n44#
+ M3_M2_CDNS_4066195314596_6/m2_n224_n658# comp018green_esd_clamp_v5p0_DVSS_0/nmos_clamp_20_50_4_DVSS_0/nmos_6p0_CDNS_406619531457_1/a_4392_n44#
+ comp018green_esd_clamp_v5p0_DVSS_0/nmos_clamp_20_50_4_DVSS_0/M2_M1_CDNS_40661953145136_3/m1_n92_n2414#
+ comp018green_esd_clamp_v5p0_DVSS_0/nmos_clamp_20_50_4_DVSS_0/nmos_6p0_CDNS_406619531457_0/a_4148_n44#
+ comp018green_esd_clamp_v5p0_DVSS_0/nmos_clamp_20_50_4_DVSS_0/nmos_6p0_CDNS_406619531457_0/a_3172_n44#
+ comp018green_esd_clamp_v5p0_DVSS_0/nmos_clamp_20_50_4_DVSS_0/nmos_6p0_CDNS_406619531457_3/a_3904_n44#
+ comp018green_esd_clamp_v5p0_DVSS_0/nmos_clamp_20_50_4_DVSS_0/nmos_6p0_CDNS_406619531457_1/a_1952_n44#
+ comp018green_esd_clamp_v5p0_DVSS_0/nmos_clamp_20_50_4_DVSS_0/nmos_6p0_CDNS_406619531457_1/a_2928_n44#
+ M3_M2_CDNS_4066195314597_18/m2_n100_n1464# comp018green_esd_clamp_v5p0_DVSS_0/nmos_clamp_20_50_4_DVSS_0/nmos_6p0_CDNS_406619531457_2/a_4392_n44#
+ comp018green_esd_clamp_v5p0_DVSS_0/nmos_clamp_20_50_4_DVSS_0/nmos_6p0_CDNS_406619531457_0/a_1708_n44#
+ comp018green_esd_clamp_v5p0_DVSS_0/nmos_clamp_20_50_4_DVSS_0/nmos_6p0_CDNS_406619531457_1/a_3172_n44#
+ comp018green_esd_clamp_v5p0_DVSS_0/nmos_clamp_20_50_4_DVSS_0/nmos_6p0_CDNS_406619531457_1/a_4148_n44#
+ comp018green_esd_clamp_v5p0_DVSS_0/nmos_6p0_CDNS_406619531458_1/a_244_n44# comp018green_esd_clamp_v5p0_DVSS_0/nmos_clamp_20_50_4_DVSS_0/nmos_6p0_CDNS_406619531457_2/a_1952_n44#
+ comp018green_esd_clamp_v5p0_DVSS_0/nmos_clamp_20_50_4_DVSS_0/nmos_6p0_CDNS_406619531457_2/a_2928_n44#
+ comp018green_esd_clamp_v5p0_DVSS_0/nmos_clamp_20_50_4_DVSS_0/nmos_6p0_CDNS_406619531457_3/a_4392_n44#
+ M3_M2_CDNS_4066195314592_24/m2_n968_n658# comp018green_esd_clamp_v5p0_DVSS_0/nmos_clamp_20_50_4_DVSS_0/nmos_6p0_CDNS_406619531457_1/a_1708_n44#
+ comp018green_esd_clamp_v5p0_DVSS_0/nmos_clamp_20_50_4_DVSS_0/nmos_6p0_CDNS_406619531457_2/a_3172_n44#
+ comp018green_esd_clamp_v5p0_DVSS_0/nmos_clamp_20_50_4_DVSS_0/nmos_6p0_CDNS_406619531457_2/a_4148_n44#
+ M3_M2_CDNS_4066195314594_22/m2_n100_n658# M2_M1_CDNS_40661953145158_6/m1_n902_n38#
+ comp018green_esd_clamp_v5p0_DVSS_0/comp018green_esd_rc_v5p0_0/ppolyf_u_CDNS_406619531453_7/PLUS
+ comp018green_esd_clamp_v5p0_DVSS_0/nmos_clamp_20_50_4_DVSS_0/nmos_6p0_CDNS_406619531457_0/a_2196_n44#
+ comp018green_esd_clamp_v5p0_DVSS_0/nmos_6p0_CDNS_406619531458_1/a_488_n44# comp018green_esd_clamp_v5p0_DVSS_0/nmos_clamp_20_50_4_DVSS_0/nmos_6p0_CDNS_406619531457_1/a_732_n44#
+ comp018green_esd_clamp_v5p0_DVSS_0/nmos_clamp_20_50_4_DVSS_0/nmos_6p0_CDNS_406619531457_3/a_1952_n44#
+ comp018green_esd_clamp_v5p0_DVSS_0/nmos_clamp_20_50_4_DVSS_0/nmos_6p0_CDNS_406619531457_3/a_2928_n44#
+ comp018green_esd_clamp_v5p0_DVSS_0/nmos_clamp_20_50_4_DVSS_0/nmos_6p0_CDNS_406619531457_2/a_1708_n44#
+ M2_M1_CDNS_40661953145158_1/m1_n902_n38# comp018green_esd_clamp_v5p0_DVSS_0/nmos_clamp_20_50_4_DVSS_0/nmos_6p0_CDNS_406619531457_1/a_0_n44#
+ comp018green_esd_clamp_v5p0_DVSS_0/nmos_clamp_20_50_4_DVSS_0/nmos_6p0_CDNS_406619531457_3/a_4148_n44#
+ comp018green_esd_clamp_v5p0_DVSS_0/nmos_clamp_20_50_4_DVSS_0/nmos_6p0_CDNS_406619531457_3/a_3172_n44#
+ M3_M2_CDNS_4066195314598_0/m2_n224_n1464# comp018green_esd_clamp_v5p0_DVSS_0/M2_M1_CDNS_40661953145159_0/m1_n714_n38#
+ comp018green_esd_clamp_v5p0_DVSS_0/nmos_clamp_20_50_4_DVSS_0/nmos_6p0_CDNS_406619531457_1/a_2196_n44#
+ comp018green_esd_clamp_v5p0_DVSS_0/nmos_clamp_20_50_4_DVSS_0/nmos_6p0_CDNS_406619531457_1/a_976_n44#
+ M3_M2_CDNS_4066195314594_15/m2_n100_n658# M3_M2_CDNS_4066195314594_27/m2_n100_n658#
+ M3_M2_CDNS_40661953145153_1/m2_n38_n632# M2_M1_CDNS_40661953145158_11/m1_n902_n38#
+ comp018green_esd_clamp_v5p0_DVSS_0/nmos_clamp_20_50_4_DVSS_0/nmos_6p0_CDNS_406619531457_3/a_1708_n44#
+ M3_M2_CDNS_4066195314590_8/m2_n906_n658# comp018green_esd_clamp_v5p0_DVSS_0/nmos_clamp_20_50_4_DVSS_0/nmos_6p0_CDNS_406619531457_2/a_2196_n44#
+ M3_M2_CDNS_4066195314590_10/m2_n906_n658# M3_M2_CDNS_40661953145152_0/m2_n38_n1496#
+ comp018green_esd_clamp_v5p0_DVSS_0/nmos_clamp_20_50_4_DVSS_0/nmos_6p0_CDNS_406619531457_3/a_2196_n44#
+ comp018green_esd_clamp_v5p0_DVSS_0/comp018green_esd_rc_v5p0_0/ppolyf_u_CDNS_406619531453_4/PLUS
+ comp018green_esd_clamp_v5p0_DVSS_0/pmos_6p0_CDNS_406619531455_0/a_3904_n44# comp018green_esd_clamp_v5p0_DVSS_0/pmos_6p0_CDNS_406619531455_0/a_5124_n44#
+ comp018green_esd_clamp_v5p0_DVSS_0/M2_M1_CDNS_40661953145125_0/m1_n142_n38# M3_M2_CDNS_4066195314596_1/m2_n224_n658#
+ comp018green_esd_clamp_v5p0_DVSS_0/nmos_clamp_20_50_4_DVSS_0/nmos_6p0_CDNS_406619531457_2/a_732_n44#
+ M3_M2_CDNS_4066195314587_13/m2_n38_n686# M3_M2_CDNS_4066195314584_7/m2_n906_n1464#
+ M3_M2_CDNS_4066195314587_8/m2_n38_n686# comp018green_esd_clamp_v5p0_DVSS_0/pmos_6p0_CDNS_406619531455_0/a_5368_n44#
+ comp018green_esd_clamp_v5p0_DVSS_0/pmos_6p0_CDNS_406619531455_0/a_4392_n44# comp018green_esd_clamp_v5p0_DVSS_0/nmos_6p0_CDNS_406619531458_0/a_0_n44#
+ comp018green_esd_clamp_v5p0_DVSS_0/nmos_clamp_20_50_4_DVSS_0/nmos_6p0_CDNS_406619531457_2/a_976_n44#
+ comp018green_esd_clamp_v5p0_DVSS_0/pmos_6p0_CDNS_406619531455_0/a_244_n44# M3_M2_CDNS_4066195314587_2/m2_n38_n686#
+ comp018green_esd_clamp_v5p0_DVSS_0/comp018green_esd_rc_v5p0_0/ppolyf_u_CDNS_406619531453_11/PLUS
+ comp018green_esd_clamp_v5p0_DVSS_0/pmos_6p0_CDNS_406619531455_0/a_1952_n44# comp018green_esd_clamp_v5p0_DVSS_0/pmos_6p0_CDNS_406619531455_0/a_2928_n44#
+ comp018green_esd_clamp_v5p0_DVSS_0/pmos_6p0_CDNS_406619531455_0/a_488_n44# comp018green_esd_clamp_v5p0_DVSS_0/nmos_clamp_20_50_4_DVSS_0/M2_M1_CDNS_40661953145136_7/m1_n92_n2414#
+ M3_M2_CDNS_4066195314594_18/m2_n100_n658# comp018green_esd_clamp_v5p0_DVSS_0/pmos_6p0_CDNS_406619531455_0/a_4148_n44#
+ comp018green_esd_clamp_v5p0_DVSS_0/pmos_6p0_CDNS_406619531455_0/a_3172_n44# comp018green_esd_clamp_v5p0_DVSS_0/comp018green_esd_rc_v5p0_0/ppolyf_u_CDNS_406619531453_0/MINUS
+ M3_M2_CDNS_4066195314589_0/m2_n38_n632# comp018green_esd_clamp_v5p0_DVSS_0/comp018green_esd_rc_v5p0_0/ppolyf_u_CDNS_406619531453_1/PLUS
+ comp018green_esd_clamp_v5p0_DVSS_0/nmos_clamp_20_50_4_DVSS_0/M2_M1_CDNS_40661953145136_2/m1_n92_n2414#
+ comp018green_esd_clamp_v5p0_DVSS_0/pmos_6p0_CDNS_406619531455_0/a_1708_n44# M3_M2_CDNS_4066195314590_13/m2_n906_n658#
+ comp018green_esd_clamp_v5p0_DVSS_0/pmos_6p0_CDNS_406619531455_0/a_0_n44# M3_M2_CDNS_40661953145152_4/m2_n38_n1496#
+ comp018green_esd_clamp_v5p0_DVSS_0/comp018green_esd_rc_v5p0_0/ppolyf_u_CDNS_406619531453_1/MINUS
+ comp018green_esd_clamp_v5p0_DVSS_0/pmos_6p0_CDNS_406619531455_0/S comp018green_esd_clamp_v5p0_DVSS_0/pmos_6p0_CDNS_406619531452_0/a_732_n44#
+ M3_M2_CDNS_4066195314594_10/m2_n100_n658# comp018green_esd_clamp_v5p0_DVSS_0/pmos_6p0_CDNS_406619531455_0/a_2196_n44#
+ comp018green_esd_clamp_v5p0_DVSS_0/nmos_clamp_20_50_4_DVSS_0/nmos_6p0_CDNS_406619531457_3/a_732_n44#
+ comp018green_esd_clamp_v5p0_DVSS_0/nmos_6p0_CDNS_406619531459_0/a_0_n44# M3_M2_CDNS_4066195314596_4/m2_n224_n658#
+ M2_M1_CDNS_40661953145158_5/m1_n902_n38# comp018green_esd_clamp_v5p0_DVSS_0/nmos_clamp_20_50_4_DVSS_0/nmos_6p0_CDNS_406619531457_3/a_976_n44#
+ comp018green_esd_clamp_v5p0_DVSS_0/comp018green_esd_rc_v5p0_0/ppolyf_u_CDNS_406619531453_2/MINUS
+ M2_M1_CDNS_40661953145158_0/m1_n902_n38# M3_M2_CDNS_4066195314597_19/m2_n100_n1464#
+ M2_M1_CDNS_40661953145158_10/m1_n902_n38# comp018green_esd_clamp_v5p0_DVSS_0/comp018green_esd_rc_v5p0_0/ppolyf_u_CDNS_406619531453_3/MINUS
+ comp018green_esd_clamp_v5p0_DVSS_0/nmos_6p0_CDNS_406619531459_0/D comp018green_esd_clamp_v5p0_DVSS_0/pmos_6p0_CDNS_406619531456_0/a_0_n44#
+ comp018green_esd_clamp_v5p0_DVSS_0/M1_POLY2_CDNS_40661953145109_0/a_n653_n42# comp018green_esd_clamp_v5p0_DVSS_0/comp018green_esd_rc_v5p0_0/ppolyf_u_CDNS_406619531453_4/MINUS
+ M3_M2_CDNS_4066195314594_6/m2_n100_n658# M3_M2_CDNS_40661953145152_6/m2_n38_n1496#
+ M3_M2_CDNS_4066195314594_13/m2_n100_n658# comp018green_esd_clamp_v5p0_DVSS_0/comp018green_esd_rc_v5p0_0/ppolyf_u_CDNS_406619531453_10/MINUS
+ comp018green_esd_clamp_v5p0_DVSS_0/M1_POLY2_CDNS_40661953145109_1/a_n653_n42# M3_M2_CDNS_4066195314594_25/m2_n100_n658#
+ M3_M2_CDNS_4066195314587_12/m2_n38_n686# M3_M2_CDNS_4066195314587_7/m2_n38_n686#
+ comp018green_esd_clamp_v5p0_DVSS_0/comp018green_esd_rc_v5p0_0/ppolyf_u_CDNS_406619531453_8/PLUS
+ comp018green_esd_clamp_v5p0_DVSS_0/comp018green_esd_rc_v5p0_0/ppolyf_u_CDNS_406619531453_5/MINUS
+ comp018green_esd_clamp_v5p0_DVSS_0/nmos_clamp_20_50_4_DVSS_0/nmos_6p0_CDNS_406619531457_2/a_0_n44#
+ M3_M2_CDNS_4066195314587_0/m2_n38_n686# comp018green_esd_clamp_v5p0_DVSS_0/comp018green_esd_rc_v5p0_0/ppolyf_u_CDNS_406619531453_11/MINUS
+ comp018green_esd_clamp_v5p0_DVSS_0/nmos_clamp_20_50_4_DVSS_0/M2_M1_CDNS_40661953145136_6/m1_n92_n2414#
+ comp018green_esd_clamp_v5p0_DVSS_0/nmos_6p0_CDNS_406619531458_0/a_732_n44# comp018green_esd_clamp_v5p0_DVSS_0/comp018green_esd_rc_v5p0_0/ppolyf_u_CDNS_406619531453_6/MINUS
+ comp018green_esd_clamp_v5p0_DVSS_0/nmos_clamp_20_50_4_DVSS_0/M2_M1_CDNS_40661953145136_1/m1_n92_n2414#
+ comp018green_esd_clamp_v5p0_DVSS_0/nmos_6p0_CDNS_406619531458_0/a_976_n44# comp018green_esd_clamp_v5p0_DVSS_0/M2_M1_CDNS_40661953145118_0/m1_n974_n38#
+ comp018green_esd_clamp_v5p0_DVSS_0/nmos_clamp_20_50_4_DVSS_0/nmos_6p0_CDNS_406619531457_3/S
+ comp018green_esd_clamp_v5p0_DVSS_0/comp018green_esd_rc_v5p0_0/ppolyf_u_CDNS_406619531453_5/PLUS
+ comp018green_esd_clamp_v5p0_DVSS_0/comp018green_esd_rc_v5p0_0/ppolyf_u_CDNS_406619531453_7/MINUS
+ M2_M1_CDNS_40661953145158_9/m1_n902_n38# M3_M2_CDNS_4066195314594_16/m2_n100_n658#
+ comp018green_esd_clamp_v5p0_DVSS_0/nmos_clamp_20_50_4_DVSS_0/nmos_6p0_CDNS_406619531457_0/a_3660_n44#
+ comp018green_esd_clamp_v5p0_DVSS_0/nmos_clamp_20_50_4_DVSS_0/nmos_6p0_CDNS_406619531457_0/a_4636_n44#
+ M2_M1_CDNS_40661953145158_4/m1_n902_n38# comp018green_esd_clamp_v5p0_DVSS_0/nmos_6p0_CDNS_406619531458_1/a_0_n44#
+ M3_M2_CDNS_4066195314590_9/m2_n906_n658# comp018green_esd_clamp_v5p0_DVSS_0/comp018green_esd_rc_v5p0_0/ppolyf_u_CDNS_406619531453_8/MINUS
+ comp018green_esd_clamp_v5p0_DVSS_0/nmos_clamp_20_50_4_DVSS_0/nmos_6p0_CDNS_406619531457_1/a_4636_n44#
+ comp018green_esd_clamp_v5p0_DVSS_0/nmos_clamp_20_50_4_DVSS_0/nmos_6p0_CDNS_406619531457_1/a_3660_n44#
+ M3_M2_CDNS_4066195314597_16/m2_n100_n1464# M3_M2_CDNS_40661953145152_2/m2_n38_n1496#
+ comp018green_esd_clamp_v5p0_DVSS_0/nmos_clamp_20_50_4_DVSS_0/nmos_6p0_CDNS_406619531457_0/a_2440_n44#
+ comp018green_esd_clamp_v5p0_DVSS_0/nmos_clamp_20_50_4_DVSS_0/nmos_6p0_CDNS_406619531457_0/a_3416_n44#
+ comp018green_esd_clamp_v5p0_DVSS_0/nmos_6p0_CDNS_406619531458_1/a_732_n44# comp018green_esd_clamp_v5p0_DVSS_0/nmos_clamp_20_50_4_DVSS_0/nmos_6p0_CDNS_406619531457_2/a_4636_n44#
+ comp018green_esd_clamp_v5p0_DVSS_0/nmos_clamp_20_50_4_DVSS_0/nmos_6p0_CDNS_406619531457_2/a_3660_n44#
+ M3_M2_CDNS_4066195314590_1/m2_n906_n658# comp018green_esd_clamp_v5p0_DVSS_0/nmos_clamp_20_50_4_DVSS_0/nmos_6p0_CDNS_406619531457_0/a_2684_n44#
+ comp018green_esd_clamp_v5p0_DVSS_0/nmos_clamp_20_50_4_DVSS_0/nmos_6p0_CDNS_406619531457_1/a_3416_n44#
+ comp018green_esd_clamp_v5p0_DVSS_0/nmos_clamp_20_50_4_DVSS_0/nmos_6p0_CDNS_406619531457_1/a_2440_n44#
+ comp018green_esd_clamp_v5p0_DVSS_0/comp018green_esd_rc_v5p0_0/ppolyf_u_CDNS_406619531453_2/PLUS
+ comp018green_esd_clamp_v5p0_DVSS_0/comp018green_esd_rc_v5p0_0/ppolyf_u_CDNS_406619531453_9/MINUS
+ comp018green_esd_clamp_v5p0_DVSS_0/nmos_clamp_20_50_4_DVSS_0/nmos_6p0_CDNS_406619531457_0/a_244_n44#
+ comp018green_esd_clamp_v5p0_DVSS_0/nmos_6p0_CDNS_406619531458_1/a_976_n44# comp018green_esd_clamp_v5p0_DVSS_0/nmos_clamp_20_50_4_DVSS_0/nmos_6p0_CDNS_406619531457_0/a_1220_n44#
+ comp018green_esd_clamp_v5p0_DVSS_0/nmos_clamp_20_50_4_DVSS_0/nmos_6p0_CDNS_406619531457_3/a_4636_n44#
+ comp018green_esd_clamp_v5p0_DVSS_0/nmos_clamp_20_50_4_DVSS_0/nmos_6p0_CDNS_406619531457_3/a_3660_n44#
+ comp018green_esd_clamp_v5p0_DVSS_0/nmos_clamp_20_50_4_DVSS_0/nmos_6p0_CDNS_406619531457_1/a_2684_n44#
+ comp018green_esd_clamp_v5p0_DVSS_0/nmos_clamp_20_50_4_DVSS_0/nmos_6p0_CDNS_406619531457_0/a_488_n44#
+ comp018green_esd_clamp_v5p0_DVSS_0/nmos_clamp_20_50_4_DVSS_0/nmos_6p0_CDNS_406619531457_2/a_2440_n44#
+ comp018green_esd_clamp_v5p0_DVSS_0/nmos_6p0_CDNS_406619531458_1/D comp018green_esd_clamp_v5p0_DVSS_0/nmos_clamp_20_50_4_DVSS_0/nmos_6p0_CDNS_406619531457_2/a_3416_n44#
+ comp018green_esd_clamp_v5p0_DVSS_0/nmos_clamp_20_50_4_DVSS_0/nmos_6p0_CDNS_406619531457_0/a_1464_n44#
+ comp018green_esd_clamp_v5p0_DVSS_0/pmos_6p0_CDNS_406619531456_0/S comp018green_esd_clamp_v5p0_DVSS_0/nmos_clamp_20_50_4_DVSS_0/nmos_6p0_CDNS_406619531457_1/a_1220_n44#
+ comp018green_esd_clamp_v5p0_DVSS_0/M2_M1_CDNS_40661953145117_1/m1_n90_n38# comp018green_esd_clamp_v5p0_DVSS_0/nmos_clamp_20_50_4_DVSS_0/nmos_6p0_CDNS_406619531457_2/a_2684_n44#
+ M3_M2_CDNS_4066195314587_11/m2_n38_n686# comp018green_esd_clamp_v5p0_DVSS_0/nmos_clamp_20_50_4_DVSS_0/nmos_6p0_CDNS_406619531457_3/a_3416_n44#
+ comp018green_esd_clamp_v5p0_DVSS_0/nmos_clamp_20_50_4_DVSS_0/nmos_6p0_CDNS_406619531457_3/a_2440_n44#
+ M3_M2_CDNS_4066195314594_19/m2_n100_n658# M3_M2_CDNS_4066195314587_5/m2_n38_n686#
+ comp018green_esd_clamp_v5p0_DVSS_0/nmos_clamp_20_50_4_DVSS_0/nmos_6p0_CDNS_406619531457_1/a_1464_n44#
+ comp018green_esd_clamp_v5p0_DVSS_0/nmos_clamp_20_50_4_DVSS_0/nmos_6p0_CDNS_406619531457_2/a_1220_n44#
+ comp018green_esd_clamp_v5p0_DVSS_0/nmos_6p0_CDNS_406619531458_1/S comp018green_esd_clamp_v5p0_DVSS_0/nmos_clamp_20_50_4_DVSS_0/nmos_6p0_CDNS_406619531457_3/a_2684_n44#
+ M3_M2_CDNS_4066195314587_1/m2_n38_n686# comp018green_esd_clamp_v5p0_DVSS_0/nmos_clamp_20_50_4_DVSS_0/nmos_6p0_CDNS_406619531457_2/a_1464_n44#
+ comp018green_esd_clamp_v5p0_DVSS_0/nmos_clamp_20_50_4_DVSS_0/nmos_6p0_CDNS_406619531457_3/a_1220_n44#
+ M3_M2_CDNS_40661953145152_5/m2_n38_n1496# comp018green_esd_clamp_v5p0_DVSS_0/nmos_clamp_20_50_4_DVSS_0/M2_M1_CDNS_40661953145136_5/m1_n92_n2414#
+ M3_M2_CDNS_4066195314594_4/m2_n100_n658# comp018green_esd_clamp_v5p0_DVSS_0/pmos_6p0_CDNS_406619531455_0/a_5612_n44#
+ M3_M2_CDNS_4066195314587_10/m2_n38_n686# comp018green_esd_clamp_v5p0_DVSS_0/nmos_clamp_20_50_4_DVSS_0/nmos_6p0_CDNS_406619531457_1/a_244_n44#
+ comp018green_esd_clamp_v5p0_DVSS_0/nmos_clamp_20_50_4_DVSS_0/nmos_6p0_CDNS_406619531457_3/a_1464_n44#
+ np_6p0_CDNS_406619531451_0/MINUS M2_M1_CDNS_4066195314586_0/m1_n92_n38# comp018green_esd_clamp_v5p0_DVSS_0/nmos_clamp_20_50_4_DVSS_0/M2_M1_CDNS_40661953145136_0/m1_n92_n2414#
+ comp018green_esd_clamp_v5p0_DVSS_0/pmos_6p0_CDNS_406619531455_0/a_4880_n44# M3_M2_CDNS_4066195314590_4/m2_n906_n658#
+ comp018green_esd_clamp_v5p0_DVSS_0/nmos_clamp_20_50_4_DVSS_0/nmos_6p0_CDNS_406619531457_1/a_488_n44#
+ comp018green_esd_clamp_v5p0_DVSS_0/pmos_6p0_CDNS_406619531455_0/a_732_n44# M3_M2_CDNS_4066195314596_5/m2_n224_n658#
+ M2_M1_CDNS_4066195314586_1/m1_n92_n38# comp018green_esd_clamp_v5p0_DVSS_0/M2_M1_CDNS_40661953145103_0/m1_n92_n92#
+ comp018green_esd_clamp_v5p0_DVSS_0/pmos_6p0_CDNS_406619531455_0/a_976_n44# np_6p0_CDNS_406619531451_1/MINUS
+ M2_M1_CDNS_40661953145158_8/m1_n902_n38# comp018green_esd_clamp_v5p0_DVSS_0/pmos_6p0_CDNS_406619531455_0/a_4636_n44#
+ comp018green_esd_clamp_v5p0_DVSS_0/pmos_6p0_CDNS_406619531455_0/a_3660_n44# comp018green_esd_clamp_v5p0_DVSS_0/pmos_6p0_CDNS_406619531455_0/D
+ M2_M1_CDNS_4066195314586_2/m1_n92_n38# comp018green_esd_clamp_v5p0_DVSS_0/M2_M1_CDNS_40661953145103_1/m1_n92_n92#
+ M2_M1_CDNS_40661953145158_3/m1_n902_n38# comp018green_esd_clamp_v5p0_DVSS_0/nmos_clamp_20_50_4_DVSS_0/nmos_6p0_CDNS_406619531457_3/a_0_n44#
+ M3_M2_CDNS_4066195314592_11/m2_n968_n658# comp018green_esd_clamp_v5p0_DVSS_0/comp018green_esd_rc_v5p0_0/ppolyf_u_CDNS_406619531453_9/PLUS
+ comp018green_esd_clamp_v5p0_DVSS_0/pmos_6p0_CDNS_406619531455_0/a_2440_n44# comp018green_esd_clamp_v5p0_DVSS_0/pmos_6p0_CDNS_406619531455_0/a_3416_n44#
+ M2_M1_CDNS_4066195314586_3/m1_n92_n38# np_6p0_CDNS_406619531451_2/MINUS M3_M2_CDNS_4066195314594_12/m2_n100_n658#
+ comp018green_esd_clamp_v5p0_DVSS_0/M1_POLY2_CDNS_40661953145106_0/a_n89_n42# comp018green_esd_clamp_v5p0_DVSS_0/nmos_clamp_20_50_4_DVSS_0/nmos_6p0_CDNS_406619531457_2/a_244_n44#
+ comp018green_esd_clamp_v5p0_DVSS_0/pmos_6p0_CDNS_406619531455_0/a_2684_n44# M3_M2_CDNS_40661953145152_7/m2_n38_n1496#
+ comp018green_esd_clamp_v5p0_DVSS_0/pmos_6p0_CDNS_406619531455_0/a_1220_n44# comp018green_esd_clamp_v5p0_DVSS_0/M2_M1_CDNS_40661953145117_2/m1_n90_n38#
+ M3_M2_CDNS_4066195314594_14/m2_n100_n658# comp018green_esd_clamp_v5p0_DVSS_0/nmos_clamp_20_50_4_DVSS_0/nmos_6p0_CDNS_406619531457_2/a_488_n44#
+ np_6p0_CDNS_406619531451_3/MINUS M3_M2_CDNS_4066195314594_20/m2_n100_n658# M3_M2_CDNS_4066195314594_26/m2_n100_n658#
+ M3_M2_CDNS_4066195314590_7/m2_n906_n658# comp018green_esd_clamp_v5p0_DVSS_0/pmos_6p0_CDNS_406619531455_0/a_1464_n44#
+ comp018green_esd_clamp_v5p0_DVSS_0/M2_M1_CDNS_40661953145117_3/m1_n90_n38# comp018green_esd_clamp_v5p0_DVSS_0/pmos_6p0_CDNS_406619531452_0/D
+ comp018green_esd_clamp_v5p0_DVSS_0/comp018green_esd_rc_v5p0_0/ppolyf_u_CDNS_406619531453_6/PLUS
+ M3_M2_CDNS_4066195314587_9/m2_n38_n686# comp018green_esd_clamp_v5p0_DVSS_0/nmos_clamp_20_50_4_DVSS_0/nmos_6p0_CDNS_406619531457_1/S
+ M3_M2_CDNS_4066195314597_17/m2_n100_n1464# M3_M2_CDNS_4066195314594_23/m2_n100_n658#
+ M3_M2_CDNS_4066195314587_4/m2_n38_n686# comp018green_esd_clamp_v5p0_DVSS_0/nmos_clamp_20_50_4_DVSS_0/nmos_6p0_CDNS_406619531457_0/a_0_n44#
+ M3_M2_CDNS_4066195314596_0/m2_n224_n658# comp018green_esd_clamp_v5p0_DVSS_0/pmos_6p0_CDNS_406619531452_0/a_244_n44#
+ M3_M2_CDNS_4066195314594_11/m2_n100_n658# comp018green_esd_clamp_v5p0_DVSS_0/nmos_clamp_20_50_4_DVSS_0/nmos_6p0_CDNS_406619531457_3/a_244_n44#
+ comp018green_esd_clamp_v5p0_DVSS_0/pmos_6p0_CDNS_406619531452_0/a_488_n44# comp018green_esd_clamp_v5p0_DVSS_0/nmos_clamp_20_50_4_DVSS_0/M2_M1_CDNS_40661953145136_4/m1_n92_n2414#
+ comp018green_esd_clamp_v5p0_DVSS_0/nmos_clamp_20_50_4_DVSS_0/nmos_6p0_CDNS_406619531457_3/a_488_n44#
+ comp018green_esd_clamp_v5p0_DVSS_0/comp018green_esd_rc_v5p0_0/ppolyf_u_CDNS_406619531453_3/PLUS
+ comp018green_esd_clamp_v5p0_DVSS_0/M1_POLY2_CDNS_40661953145105_0/a_n371_n42# M3_M2_CDNS_4066195314590_12/m2_n906_n658#
+ M2_M1_CDNS_40661953145158_7/m1_n902_n38# M3_M2_CDNS_4066195314594_9/m2_n100_n658#
+ M3_M2_CDNS_40661953145152_1/m2_n38_n1496# comp018green_esd_clamp_v5p0_DVSS_0/comp018green_esd_rc_v5p0_0/ppolyf_u_CDNS_406619531453_10/PLUS
+ M2_M1_CDNS_40661953145158_2/m1_n902_n38# M2_M1_CDNS_4066195314573_3/m1_n92_n146#
+ comp018green_esd_clamp_v5p0_DVSS_0/M2_M1_CDNS_40661953145159_1/m1_n714_n38# M3_M2_CDNS_4066195314590_2/m2_n906_n658#
+ comp018green_esd_clamp_v5p0_DVSS_0/nmos_6p0_CDNS_406619531459_0/S comp018green_esd_clamp_v5p0_DVSS_0/nmos_clamp_20_50_4_DVSS_0/nmos_6p0_CDNS_406619531457_3/D
+ M3_M2_CDNS_4066195314584_6/m2_n906_n1464# M3_M2_CDNS_4066195314592_17/m2_n968_n658#
+ VSUBS comp018green_esd_clamp_v5p0_DVSS_0/nmos_clamp_20_50_4_DVSS_0/nmos_6p0_CDNS_406619531457_2/D
+ comp018green_esd_clamp_v5p0_DVSS_0/nmos_clamp_20_50_4_DVSS_0/nmos_6p0_CDNS_406619531457_0/D
+ comp018green_esd_clamp_v5p0_DVSS_0/comp018green_esd_rc_v5p0_0/ppolyf_u_CDNS_406619531453_0/PLUS
Xcomp018green_esd_clamp_v5p0_DVSS_0 comp018green_esd_clamp_v5p0_DVSS_0/pmos_6p0_CDNS_406619531452_0/a_244_n44#
+ comp018green_esd_clamp_v5p0_DVSS_0/pmos_6p0_CDNS_406619531452_0/D comp018green_esd_clamp_v5p0_DVSS_0/pmos_6p0_CDNS_406619531452_0/a_488_n44#
+ comp018green_esd_clamp_v5p0_DVSS_0/comp018green_esd_rc_v5p0_0/ppolyf_u_CDNS_406619531453_8/PLUS
+ comp018green_esd_clamp_v5p0_DVSS_0/nmos_clamp_20_50_4_DVSS_0/nmos_6p0_CDNS_406619531457_0/a_732_n44#
+ comp018green_esd_clamp_v5p0_DVSS_0/nmos_clamp_20_50_4_DVSS_0/nmos_6p0_CDNS_406619531457_0/a_976_n44#
+ comp018green_esd_clamp_v5p0_DVSS_0/nmos_clamp_20_50_4_DVSS_0/nmos_6p0_CDNS_406619531457_1/a_0_n44#
+ comp018green_esd_clamp_v5p0_DVSS_0/M1_POLY2_CDNS_40661953145106_0/a_n89_n42# comp018green_esd_clamp_v5p0_DVSS_0/nmos_clamp_20_50_4_DVSS_0/nmos_6p0_CDNS_406619531457_0/a_3904_n44#
+ comp018green_esd_clamp_v5p0_DVSS_0/comp018green_esd_rc_v5p0_0/ppolyf_u_CDNS_406619531453_10/PLUS
+ comp018green_esd_clamp_v5p0_DVSS_0/comp018green_esd_rc_v5p0_0/ppolyf_u_CDNS_406619531453_5/PLUS
+ comp018green_esd_clamp_v5p0_DVSS_0/nmos_clamp_20_50_4_DVSS_0/nmos_6p0_CDNS_406619531457_1/a_3904_n44#
+ comp018green_esd_clamp_v5p0_DVSS_0/nmos_clamp_20_50_4_DVSS_0/M2_M1_CDNS_40661953145136_7/m1_n92_n2414#
+ comp018green_esd_clamp_v5p0_DVSS_0/nmos_clamp_20_50_4_DVSS_0/nmos_6p0_CDNS_406619531457_0/a_4392_n44#
+ comp018green_esd_clamp_v5p0_DVSS_0/nmos_clamp_20_50_4_DVSS_0/nmos_6p0_CDNS_406619531457_1/a_732_n44#
+ comp018green_esd_clamp_v5p0_DVSS_0/nmos_clamp_20_50_4_DVSS_0/M2_M1_CDNS_40661953145136_2/m1_n92_n2414#
+ comp018green_esd_clamp_v5p0_DVSS_0/nmos_clamp_20_50_4_DVSS_0/nmos_6p0_CDNS_406619531457_2/a_3904_n44#
+ comp018green_esd_clamp_v5p0_DVSS_0/nmos_clamp_20_50_4_DVSS_0/nmos_6p0_CDNS_406619531457_0/a_2928_n44#
+ comp018green_esd_clamp_v5p0_DVSS_0/nmos_clamp_20_50_4_DVSS_0/nmos_6p0_CDNS_406619531457_0/a_1952_n44#
+ comp018green_esd_clamp_v5p0_DVSS_0/nmos_clamp_20_50_4_DVSS_0/nmos_6p0_CDNS_406619531457_1/a_976_n44#
+ comp018green_esd_clamp_v5p0_DVSS_0/nmos_clamp_20_50_4_DVSS_0/nmos_6p0_CDNS_406619531457_1/a_4392_n44#
+ comp018green_esd_clamp_v5p0_DVSS_0/nmos_clamp_20_50_4_DVSS_0/nmos_6p0_CDNS_406619531457_0/a_4148_n44#
+ comp018green_esd_clamp_v5p0_DVSS_0/nmos_clamp_20_50_4_DVSS_0/nmos_6p0_CDNS_406619531457_0/a_3172_n44#
+ comp018green_esd_clamp_v5p0_DVSS_0/pmos_6p0_CDNS_406619531455_0/a_5612_n44# comp018green_esd_clamp_v5p0_DVSS_0/nmos_clamp_20_50_4_DVSS_0/nmos_6p0_CDNS_406619531457_1/a_1952_n44#
+ comp018green_esd_clamp_v5p0_DVSS_0/nmos_clamp_20_50_4_DVSS_0/nmos_6p0_CDNS_406619531457_1/a_2928_n44#
+ comp018green_esd_clamp_v5p0_DVSS_0/nmos_clamp_20_50_4_DVSS_0/nmos_6p0_CDNS_406619531457_3/a_3904_n44#
+ comp018green_esd_clamp_v5p0_DVSS_0/nmos_6p0_CDNS_406619531458_0/a_244_n44# comp018green_esd_clamp_v5p0_DVSS_0/nmos_6p0_CDNS_406619531459_0/S
+ comp018green_esd_clamp_v5p0_DVSS_0/nmos_clamp_20_50_4_DVSS_0/nmos_6p0_CDNS_406619531457_2/a_4392_n44#
+ comp018green_esd_clamp_v5p0_DVSS_0/nmos_clamp_20_50_4_DVSS_0/nmos_6p0_CDNS_406619531457_0/a_1708_n44#
+ comp018green_esd_clamp_v5p0_DVSS_0/nmos_clamp_20_50_4_DVSS_0/nmos_6p0_CDNS_406619531457_1/a_3172_n44#
+ comp018green_esd_clamp_v5p0_DVSS_0/pmos_6p0_CDNS_406619531456_0/a_244_n44# comp018green_esd_clamp_v5p0_DVSS_0/nmos_clamp_20_50_4_DVSS_0/nmos_6p0_CDNS_406619531457_1/a_4148_n44#
+ comp018green_esd_clamp_v5p0_DVSS_0/nmos_6p0_CDNS_406619531458_0/a_488_n44# comp018green_esd_clamp_v5p0_DVSS_0/pmos_6p0_CDNS_406619531455_0/a_4880_n44#
+ M3_M2_CDNS_4066195314596_4/m2_n224_n658# comp018green_esd_clamp_v5p0_DVSS_0/comp018green_esd_rc_v5p0_0/ppolyf_u_CDNS_406619531453_2/PLUS
+ comp018green_esd_clamp_v5p0_DVSS_0/nmos_clamp_20_50_4_DVSS_0/nmos_6p0_CDNS_406619531457_2/a_1952_n44#
+ comp018green_esd_clamp_v5p0_DVSS_0/nmos_clamp_20_50_4_DVSS_0/nmos_6p0_CDNS_406619531457_2/a_2928_n44#
+ comp018green_esd_clamp_v5p0_DVSS_0/nmos_clamp_20_50_4_DVSS_0/nmos_6p0_CDNS_406619531457_3/a_4392_n44#
+ comp018green_esd_clamp_v5p0_DVSS_0/nmos_clamp_20_50_4_DVSS_0/nmos_6p0_CDNS_406619531457_2/a_3172_n44#
+ comp018green_esd_clamp_v5p0_DVSS_0/nmos_clamp_20_50_4_DVSS_0/nmos_6p0_CDNS_406619531457_2/a_4148_n44#
+ comp018green_esd_clamp_v5p0_DVSS_0/nmos_clamp_20_50_4_DVSS_0/nmos_6p0_CDNS_406619531457_1/a_1708_n44#
+ comp018green_esd_clamp_v5p0_DVSS_0/pmos_6p0_CDNS_406619531456_0/a_488_n44# comp018green_esd_clamp_v5p0_DVSS_0/nmos_clamp_20_50_4_DVSS_0/nmos_6p0_CDNS_406619531457_0/a_2196_n44#
+ comp018green_esd_clamp_v5p0_DVSS_0/nmos_6p0_CDNS_406619531458_0/a_0_n44# comp018green_esd_clamp_v5p0_DVSS_0/pmos_6p0_CDNS_406619531455_0/a_3660_n44#
+ comp018green_esd_clamp_v5p0_DVSS_0/nmos_clamp_20_50_4_DVSS_0/nmos_6p0_CDNS_406619531457_3/a_1952_n44#
+ comp018green_esd_clamp_v5p0_DVSS_0/nmos_clamp_20_50_4_DVSS_0/nmos_6p0_CDNS_406619531457_3/a_2928_n44#
+ comp018green_esd_clamp_v5p0_DVSS_0/pmos_6p0_CDNS_406619531455_0/a_4636_n44# comp018green_esd_clamp_v5p0_DVSS_0/nmos_clamp_20_50_4_DVSS_0/nmos_6p0_CDNS_406619531457_2/a_1708_n44#
+ comp018green_esd_clamp_v5p0_DVSS_0/nmos_clamp_20_50_4_DVSS_0/nmos_6p0_CDNS_406619531457_2/a_732_n44#
+ comp018green_esd_clamp_v5p0_DVSS_0/nmos_clamp_20_50_4_DVSS_0/nmos_6p0_CDNS_406619531457_3/a_3172_n44#
+ comp018green_esd_clamp_v5p0_DVSS_0/nmos_clamp_20_50_4_DVSS_0/nmos_6p0_CDNS_406619531457_3/a_4148_n44#
+ comp018green_esd_clamp_v5p0_DVSS_0/nmos_clamp_20_50_4_DVSS_0/nmos_6p0_CDNS_406619531457_1/a_2196_n44#
+ comp018green_esd_clamp_v5p0_DVSS_0/nmos_clamp_20_50_4_DVSS_0/nmos_6p0_CDNS_406619531457_2/a_976_n44#
+ comp018green_esd_clamp_v5p0_DVSS_0/pmos_6p0_CDNS_406619531456_0/D comp018green_esd_clamp_v5p0_DVSS_0/pmos_6p0_CDNS_406619531455_0/a_2440_n44#
+ comp018green_esd_clamp_v5p0_DVSS_0/pmos_6p0_CDNS_406619531455_0/a_3416_n44# comp018green_esd_clamp_v5p0_DVSS_0/nmos_clamp_20_50_4_DVSS_0/nmos_6p0_CDNS_406619531457_3/a_1708_n44#
+ comp018green_esd_clamp_v5p0_DVSS_0/nmos_clamp_20_50_4_DVSS_0/nmos_6p0_CDNS_406619531457_2/a_2196_n44#
+ comp018green_esd_clamp_v5p0_DVSS_0/nmos_6p0_CDNS_406619531458_1/a_244_n44# comp018green_esd_clamp_v5p0_DVSS_0/pmos_6p0_CDNS_406619531455_0/a_0_n44#
+ comp018green_esd_clamp_v5p0_DVSS_0/M1_POLY2_CDNS_40661953145110_0/a_n2862_n42# comp018green_esd_clamp_v5p0_DVSS_0/pmos_6p0_CDNS_406619531455_0/a_2684_n44#
+ comp018green_esd_clamp_v5p0_DVSS_0/pmos_6p0_CDNS_406619531455_0/a_1220_n44# comp018green_esd_clamp_v5p0_DVSS_0/nmos_6p0_CDNS_406619531458_1/a_488_n44#
+ comp018green_esd_clamp_v5p0_DVSS_0/nmos_clamp_20_50_4_DVSS_0/nmos_6p0_CDNS_406619531457_3/a_2196_n44#
+ comp018green_esd_clamp_v5p0_DVSS_0/nmos_6p0_CDNS_406619531458_0/D comp018green_esd_clamp_v5p0_DVSS_0/nmos_6p0_CDNS_406619531459_0/a_0_n44#
+ comp018green_esd_clamp_v5p0_DVSS_0/pmos_6p0_CDNS_406619531455_0/a_1464_n44# comp018green_esd_clamp_v5p0_DVSS_0/M1_POLY2_CDNS_40661953145109_0/a_n653_n42#
+ comp018green_esd_clamp_v5p0_DVSS_0/nmos_clamp_20_50_4_DVSS_0/nmos_6p0_CDNS_406619531457_3/S
+ comp018green_esd_clamp_v5p0_DVSS_0/nmos_clamp_20_50_4_DVSS_0/nmos_6p0_CDNS_406619531457_3/a_732_n44#
+ comp018green_esd_clamp_v5p0_DVSS_0/M1_POLY2_CDNS_40661953145109_1/a_n653_n42# comp018green_esd_clamp_v5p0_DVSS_0/nmos_clamp_20_50_4_DVSS_0/M2_M1_CDNS_40661953145136_6/m1_n92_n2414#
+ comp018green_esd_clamp_v5p0_DVSS_0/nmos_clamp_20_50_4_DVSS_0/nmos_6p0_CDNS_406619531457_3/a_976_n44#
+ comp018green_esd_clamp_v5p0_DVSS_0/nmos_clamp_20_50_4_DVSS_0/M2_M1_CDNS_40661953145136_1/m1_n92_n2414#
+ comp018green_esd_clamp_v5p0_DVSS_0/pmos_6p0_CDNS_406619531456_0/a_0_n44# comp018green_esd_clamp_v5p0_DVSS_0/comp018green_esd_rc_v5p0_0/ppolyf_u_CDNS_406619531453_9/PLUS
+ comp018green_esd_clamp_v5p0_DVSS_0/nmos_clamp_20_50_4_DVSS_0/nmos_6p0_CDNS_406619531457_2/a_0_n44#
+ comp018green_esd_clamp_v5p0_DVSS_0/pmos_6p0_CDNS_406619531455_0/a_244_n44# comp018green_esd_clamp_v5p0_DVSS_0/pmos_6p0_CDNS_406619531455_0/a_488_n44#
+ comp018green_esd_clamp_v5p0_DVSS_0/comp018green_esd_rc_v5p0_0/ppolyf_u_CDNS_406619531453_11/PLUS
+ comp018green_esd_clamp_v5p0_DVSS_0/comp018green_esd_rc_v5p0_0/ppolyf_u_CDNS_406619531453_6/PLUS
+ comp018green_esd_clamp_v5p0_DVSS_0/M2_M1_CDNS_40661953145159_1/m1_n714_n38# comp018green_esd_clamp_v5p0_DVSS_0/comp018green_esd_rc_v5p0_0/ppolyf_u_CDNS_406619531453_0/MINUS
+ comp018green_esd_clamp_v5p0_DVSS_0/pmos_6p0_CDNS_406619531452_0/a_732_n44# comp018green_esd_clamp_v5p0_DVSS_0/comp018green_esd_rc_v5p0_0/ppolyf_u_CDNS_406619531453_1/MINUS
+ comp018green_esd_clamp_v5p0_DVSS_0/nmos_6p0_CDNS_406619531458_0/a_1220_n44# comp018green_esd_clamp_v5p0_DVSS_0/M2_M1_CDNS_40661953145113_0/m1_n454_n38#
+ comp018green_esd_clamp_v5p0_DVSS_0/comp018green_esd_rc_v5p0_0/ppolyf_u_CDNS_406619531453_3/PLUS
+ comp018green_esd_clamp_v5p0_DVSS_0/nmos_6p0_CDNS_406619531458_1/a_0_n44# comp018green_esd_clamp_v5p0_DVSS_0/M2_M1_CDNS_40661953145125_1/m1_n142_n38#
+ comp018green_esd_clamp_v5p0_DVSS_0/comp018green_esd_rc_v5p0_0/ppolyf_u_CDNS_406619531453_2/MINUS
+ comp018green_esd_clamp_v5p0_DVSS_0/nmos_6p0_CDNS_406619531458_1/a_1220_n44# comp018green_esd_clamp_v5p0_DVSS_0/pmos_6p0_CDNS_406619531455_0/S
+ comp018green_esd_clamp_v5p0_DVSS_0/nmos_clamp_20_50_4_DVSS_0/M2_M1_CDNS_40661953145136_5/m1_n92_n2414#
+ comp018green_esd_clamp_v5p0_DVSS_0/comp018green_esd_rc_v5p0_0/ppolyf_u_CDNS_406619531453_3/MINUS
+ comp018green_esd_clamp_v5p0_DVSS_0/nmos_clamp_20_50_4_DVSS_0/M2_M1_CDNS_40661953145136_0/m1_n92_n2414#
+ comp018green_esd_clamp_v5p0_DVSS_0/comp018green_esd_rc_v5p0_0/ppolyf_u_CDNS_406619531453_0/PLUS
+ comp018green_esd_clamp_v5p0_DVSS_0/nmos_6p0_CDNS_406619531459_0/D comp018green_esd_clamp_v5p0_DVSS_0/nmos_clamp_20_50_4_DVSS_0/nmos_6p0_CDNS_406619531457_0/a_244_n44#
+ comp018green_esd_clamp_v5p0_DVSS_0/comp018green_esd_rc_v5p0_0/ppolyf_u_CDNS_406619531453_4/MINUS
+ comp018green_esd_clamp_v5p0_DVSS_0/comp018green_esd_rc_v5p0_0/ppolyf_u_CDNS_406619531453_10/MINUS
+ comp018green_esd_clamp_v5p0_DVSS_0/nmos_clamp_20_50_4_DVSS_0/nmos_6p0_CDNS_406619531457_0/a_488_n44#
+ comp018green_esd_clamp_v5p0_DVSS_0/comp018green_esd_rc_v5p0_0/ppolyf_u_CDNS_406619531453_5/MINUS
+ comp018green_esd_clamp_v5p0_DVSS_0/nmos_clamp_20_50_4_DVSS_0/nmos_6p0_CDNS_406619531457_0/a_3660_n44#
+ comp018green_esd_clamp_v5p0_DVSS_0/nmos_clamp_20_50_4_DVSS_0/nmos_6p0_CDNS_406619531457_0/a_4636_n44#
+ comp018green_esd_clamp_v5p0_DVSS_0/nmos_6p0_CDNS_406619531458_0/a_732_n44# comp018green_esd_clamp_v5p0_DVSS_0/comp018green_esd_rc_v5p0_0/ppolyf_u_CDNS_406619531453_11/MINUS
+ comp018green_esd_clamp_v5p0_DVSS_0/nmos_clamp_20_50_4_DVSS_0/nmos_6p0_CDNS_406619531457_1/a_3660_n44#
+ comp018green_esd_clamp_v5p0_DVSS_0/nmos_clamp_20_50_4_DVSS_0/nmos_6p0_CDNS_406619531457_1/a_4636_n44#
+ comp018green_esd_clamp_v5p0_DVSS_0/M2_M1_CDNS_40661953145159_0/m1_n714_n38# comp018green_esd_clamp_v5p0_DVSS_0/nmos_clamp_20_50_4_DVSS_0/nmos_6p0_CDNS_406619531457_0/a_2440_n44#
+ comp018green_esd_clamp_v5p0_DVSS_0/nmos_clamp_20_50_4_DVSS_0/nmos_6p0_CDNS_406619531457_0/a_3416_n44#
+ comp018green_esd_clamp_v5p0_DVSS_0/nmos_6p0_CDNS_406619531458_0/a_976_n44# comp018green_esd_clamp_v5p0_DVSS_0/comp018green_esd_rc_v5p0_0/ppolyf_u_CDNS_406619531453_6/MINUS
+ comp018green_esd_clamp_v5p0_DVSS_0/nmos_clamp_20_50_4_DVSS_0/nmos_6p0_CDNS_406619531457_2/a_4636_n44#
+ comp018green_esd_clamp_v5p0_DVSS_0/nmos_clamp_20_50_4_DVSS_0/nmos_6p0_CDNS_406619531457_2/a_3660_n44#
+ comp018green_esd_clamp_v5p0_DVSS_0/nmos_clamp_20_50_4_DVSS_0/nmos_6p0_CDNS_406619531457_0/a_2684_n44#
+ comp018green_esd_clamp_v5p0_DVSS_0/nmos_clamp_20_50_4_DVSS_0/nmos_6p0_CDNS_406619531457_3/a_0_n44#
+ comp018green_esd_clamp_v5p0_DVSS_0/nmos_clamp_20_50_4_DVSS_0/nmos_6p0_CDNS_406619531457_1/a_2440_n44#
+ comp018green_esd_clamp_v5p0_DVSS_0/nmos_clamp_20_50_4_DVSS_0/nmos_6p0_CDNS_406619531457_1/a_3416_n44#
+ comp018green_esd_clamp_v5p0_DVSS_0/nmos_clamp_20_50_4_DVSS_0/nmos_6p0_CDNS_406619531457_0/a_1220_n44#
+ comp018green_esd_clamp_v5p0_DVSS_0/nmos_clamp_20_50_4_DVSS_0/nmos_6p0_CDNS_406619531457_1/a_244_n44#
+ comp018green_esd_clamp_v5p0_DVSS_0/comp018green_esd_rc_v5p0_0/ppolyf_u_CDNS_406619531453_7/MINUS
+ comp018green_esd_clamp_v5p0_DVSS_0/nmos_clamp_20_50_4_DVSS_0/nmos_6p0_CDNS_406619531457_2/a_2440_n44#
+ comp018green_esd_clamp_v5p0_DVSS_0/nmos_clamp_20_50_4_DVSS_0/nmos_6p0_CDNS_406619531457_1/a_2684_n44#
+ comp018green_esd_clamp_v5p0_DVSS_0/nmos_clamp_20_50_4_DVSS_0/nmos_6p0_CDNS_406619531457_3/a_3660_n44#
+ comp018green_esd_clamp_v5p0_DVSS_0/nmos_clamp_20_50_4_DVSS_0/nmos_6p0_CDNS_406619531457_3/a_4636_n44#
+ comp018green_esd_clamp_v5p0_DVSS_0/nmos_clamp_20_50_4_DVSS_0/nmos_6p0_CDNS_406619531457_1/S
+ comp018green_esd_clamp_v5p0_DVSS_0/nmos_clamp_20_50_4_DVSS_0/nmos_6p0_CDNS_406619531457_2/a_3416_n44#
+ comp018green_esd_clamp_v5p0_DVSS_0/nmos_clamp_20_50_4_DVSS_0/nmos_6p0_CDNS_406619531457_0/a_1464_n44#
+ comp018green_esd_clamp_v5p0_DVSS_0/nmos_clamp_20_50_4_DVSS_0/nmos_6p0_CDNS_406619531457_1/a_1220_n44#
+ comp018green_esd_clamp_v5p0_DVSS_0/nmos_clamp_20_50_4_DVSS_0/nmos_6p0_CDNS_406619531457_1/a_488_n44#
+ comp018green_esd_clamp_v5p0_DVSS_0/pmos_6p0_CDNS_406619531455_0/a_3904_n44# comp018green_esd_clamp_v5p0_DVSS_0/nmos_clamp_20_50_4_DVSS_0/nmos_6p0_CDNS_406619531457_2/a_2684_n44#
+ comp018green_esd_clamp_v5p0_DVSS_0/nmos_clamp_20_50_4_DVSS_0/nmos_6p0_CDNS_406619531457_3/a_2440_n44#
+ comp018green_esd_clamp_v5p0_DVSS_0/nmos_clamp_20_50_4_DVSS_0/nmos_6p0_CDNS_406619531457_3/a_3416_n44#
+ comp018green_esd_clamp_v5p0_DVSS_0/pmos_6p0_CDNS_406619531455_0/a_5124_n44# comp018green_esd_clamp_v5p0_DVSS_0/M2_M1_CDNS_40661953145125_0/m1_n142_n38#
+ comp018green_esd_clamp_v5p0_DVSS_0/nmos_6p0_CDNS_406619531458_1/a_732_n44# comp018green_esd_clamp_v5p0_DVSS_0/nmos_clamp_20_50_4_DVSS_0/nmos_6p0_CDNS_406619531457_2/a_1220_n44#
+ comp018green_esd_clamp_v5p0_DVSS_0/nmos_clamp_20_50_4_DVSS_0/nmos_6p0_CDNS_406619531457_1/a_1464_n44#
+ M3_M2_CDNS_4066195314594_20/m2_n100_n658# comp018green_esd_clamp_v5p0_DVSS_0/comp018green_esd_rc_v5p0_0/ppolyf_u_CDNS_406619531453_8/MINUS
+ comp018green_esd_clamp_v5p0_DVSS_0/pmos_6p0_CDNS_406619531455_0/a_4392_n44# comp018green_esd_clamp_v5p0_DVSS_0/pmos_6p0_CDNS_406619531455_0/a_5368_n44#
+ comp018green_esd_clamp_v5p0_DVSS_0/nmos_6p0_CDNS_406619531458_1/a_976_n44# comp018green_esd_clamp_v5p0_DVSS_0/nmos_clamp_20_50_4_DVSS_0/M2_M1_CDNS_40661953145136_4/m1_n92_n2414#
+ comp018green_esd_clamp_v5p0_DVSS_0/nmos_clamp_20_50_4_DVSS_0/nmos_6p0_CDNS_406619531457_3/a_2684_n44#
+ comp018green_esd_clamp_v5p0_DVSS_0/comp018green_esd_rc_v5p0_0/ppolyf_u_CDNS_406619531453_7/PLUS
+ comp018green_esd_clamp_v5p0_DVSS_0/nmos_clamp_20_50_4_DVSS_0/nmos_6p0_CDNS_406619531457_2/a_1464_n44#
+ comp018green_esd_clamp_v5p0_DVSS_0/nmos_clamp_20_50_4_DVSS_0/nmos_6p0_CDNS_406619531457_3/a_1220_n44#
+ comp018green_esd_clamp_v5p0_DVSS_0/pmos_6p0_CDNS_406619531455_0/a_2928_n44# comp018green_esd_clamp_v5p0_DVSS_0/pmos_6p0_CDNS_406619531455_0/a_1952_n44#
+ comp018green_esd_clamp_v5p0_DVSS_0/pmos_6p0_CDNS_406619531455_0/a_3172_n44# comp018green_esd_clamp_v5p0_DVSS_0/pmos_6p0_CDNS_406619531455_0/a_4148_n44#
+ comp018green_esd_clamp_v5p0_DVSS_0/comp018green_esd_rc_v5p0_0/ppolyf_u_CDNS_406619531453_9/MINUS
+ comp018green_esd_clamp_v5p0_DVSS_0/nmos_clamp_20_50_4_DVSS_0/nmos_6p0_CDNS_406619531457_0/a_0_n44#
+ comp018green_esd_clamp_v5p0_DVSS_0/nmos_clamp_20_50_4_DVSS_0/nmos_6p0_CDNS_406619531457_3/a_1464_n44#
+ M3_M2_CDNS_4066195314594_23/m2_n100_n658# comp018green_esd_clamp_v5p0_DVSS_0/nmos_clamp_20_50_4_DVSS_0/nmos_6p0_CDNS_406619531457_2/a_244_n44#
+ comp018green_esd_clamp_v5p0_DVSS_0/pmos_6p0_CDNS_406619531455_0/a_1708_n44# comp018green_esd_clamp_v5p0_DVSS_0/nmos_clamp_20_50_4_DVSS_0/nmos_6p0_CDNS_406619531457_2/a_488_n44#
+ M3_M2_CDNS_4066195314594_11/m2_n100_n658# comp018green_esd_clamp_v5p0_DVSS_0/comp018green_esd_rc_v5p0_0/ppolyf_u_CDNS_406619531453_4/PLUS
+ comp018green_esd_clamp_v5p0_DVSS_0/M1_POLY2_CDNS_40661953145105_0/a_n371_n42# comp018green_esd_clamp_v5p0_DVSS_0/pmos_6p0_CDNS_406619531455_0/a_2196_n44#
+ comp018green_esd_clamp_v5p0_DVSS_0/nmos_6p0_CDNS_406619531458_1/D comp018green_esd_clamp_v5p0_DVSS_0/pmos_6p0_CDNS_406619531456_0/S
+ M2_M1_CDNS_4066195314573_3/m1_n92_n146# comp018green_esd_clamp_v5p0_DVSS_0/pmos_6p0_CDNS_406619531455_0/a_732_n44#
+ M3_M2_CDNS_4066195314594_9/m2_n100_n658# comp018green_esd_clamp_v5p0_DVSS_0/nmos_clamp_20_50_4_DVSS_0/nmos_6p0_CDNS_406619531457_3/a_244_n44#
+ comp018green_esd_clamp_v5p0_DVSS_0/M2_M1_CDNS_40661953145103_0/m1_n92_n92# comp018green_esd_clamp_v5p0_DVSS_0/nmos_6p0_CDNS_406619531458_1/S
+ comp018green_esd_clamp_v5p0_DVSS_0/pmos_6p0_CDNS_406619531455_0/a_976_n44# comp018green_esd_clamp_v5p0_DVSS_0/nmos_clamp_20_50_4_DVSS_0/nmos_6p0_CDNS_406619531457_3/a_488_n44#
+ comp018green_esd_clamp_v5p0_DVSS_0/M2_M1_CDNS_40661953145103_1/m1_n92_n92# comp018green_esd_clamp_v5p0_DVSS_0/comp018green_esd_rc_v5p0_0/ppolyf_u_CDNS_406619531453_1/PLUS
+ comp018green_esd_clamp_v5p0_DVSS_0/M2_M1_CDNS_40661953145117_2/m1_n90_n38# comp018green_esd_clamp_v5p0_DVSS_0/nmos_clamp_20_50_4_DVSS_0/M2_M1_CDNS_40661953145136_3/m1_n92_n2414#
+ comp018green_esd_clamp_v5p0_DVSS_0/pmos_6p0_CDNS_406619531455_0/D comp018green_esd_clamp_v5p0_DVSS_0/M1_POLY2_CDNS_40661953145108_0/a_n277_n42#
+ comp018green_esd_clamp_v5p0_DVSS_0/M2_M1_CDNS_40661953145117_3/m1_n90_n38# comp018green_esd_clamp_v5p0_DVSS_0/M2_M1_CDNS_40661953145117_1/m1_n90_n38#
+ comp018green_esd_clamp_v5p0_DVSS_0/nmos_clamp_20_50_4_DVSS_0/nmos_6p0_CDNS_406619531457_3/D
+ comp018green_esd_clamp_v5p0_DVSS_0/nmos_clamp_20_50_4_DVSS_0/nmos_6p0_CDNS_406619531457_2/D
+ comp018green_esd_clamp_v5p0_DVSS_0/nmos_clamp_20_50_4_DVSS_0/nmos_6p0_CDNS_406619531457_0/D
+ VSUBS comp018green_esd_clamp_v5p0_DVSS_0/nmos_clamp_20_50_4_DVSS_0/nmos_6p0_CDNS_406619531457_3/D
+ comp018green_esd_clamp_v5p0_DVSS_0/nmos_clamp_20_50_4_DVSS_0/nmos_6p0_CDNS_406619531457_3/D
+ VSUBS VSUBS comp018green_esd_clamp_v5p0_DVSS_0/pmos_6p0_CDNS_406619531452_0/a_0_n44#
+ comp018green_esd_clamp_v5p0_DVSS_0/M2_M1_CDNS_40661953145118_0/m1_n974_n38# comp018green_esd_clamp_v5p0_DVSS
Xnp_6p0_CDNS_406619531451_0 np_6p0_CDNS_406619531451_0/MINUS VSUBS np_6p0_CDNS_406619531451
Xnp_6p0_CDNS_406619531451_1 np_6p0_CDNS_406619531451_1/MINUS VSUBS np_6p0_CDNS_406619531451
Xnp_6p0_CDNS_406619531451_2 np_6p0_CDNS_406619531451_2/MINUS VSUBS np_6p0_CDNS_406619531451
Xnp_6p0_CDNS_406619531451_3 np_6p0_CDNS_406619531451_3/MINUS VSUBS np_6p0_CDNS_406619531451
.ends

.subckt gf180mcu_fd_io__dvss DVDD VDD DVSS
XGF_NI_DVSS_BASE_0 DVSS DVSS GF_NI_DVSS_BASE_0/comp018green_esd_clamp_v5p0_DVSS_0/pmos_6p0_CDNS_406619531456_0/D
+ DVSS DVSS GF_NI_DVSS_BASE_0/comp018green_esd_clamp_v5p0_DVSS_0/pmos_6p0_CDNS_406619531455_0/D
+ GF_NI_DVSS_BASE_0/comp018green_esd_clamp_v5p0_DVSS_0/pmos_6p0_CDNS_406619531456_0/D
+ GF_NI_DVSS_BASE_0/comp018green_esd_clamp_v5p0_DVSS_0/comp018green_esd_rc_v5p0_0/ppolyf_u_CDNS_406619531453_0/MINUS
+ GF_NI_DVSS_BASE_0/comp018green_esd_clamp_v5p0_DVSS_0/pmos_6p0_CDNS_406619531452_0/D
+ DVSS GF_NI_DVSS_BASE_0/comp018green_esd_clamp_v5p0_DVSS_0/pmos_6p0_CDNS_406619531456_0/D
+ GF_NI_DVSS_BASE_0/comp018green_esd_clamp_v5p0_DVSS_0/pmos_6p0_CDNS_406619531456_0/D
+ GF_NI_DVSS_BASE_0/comp018green_esd_clamp_v5p0_DVSS_0/pmos_6p0_CDNS_406619531452_0/D
+ DVDD DVSS DVSS GF_NI_DVSS_BASE_0/comp018green_esd_clamp_v5p0_DVSS_0/pmos_6p0_CDNS_406619531456_0/D
+ GF_NI_DVSS_BASE_0/comp018green_esd_clamp_v5p0_DVSS_0/pmos_6p0_CDNS_406619531455_0/D
+ GF_NI_DVSS_BASE_0/comp018green_esd_clamp_v5p0_DVSS_0/pmos_6p0_CDNS_406619531455_0/D
+ GF_NI_DVSS_BASE_0/comp018green_esd_clamp_v5p0_DVSS_0/pmos_6p0_CDNS_406619531452_0/D
+ GF_NI_DVSS_BASE_0/comp018green_esd_clamp_v5p0_DVSS_0/pmos_6p0_CDNS_406619531455_0/D
+ DVDD GF_NI_DVSS_BASE_0/comp018green_esd_clamp_v5p0_DVSS_0/pmos_6p0_CDNS_406619531452_0/D
+ GF_NI_DVSS_BASE_0/comp018green_esd_clamp_v5p0_DVSS_0/pmos_6p0_CDNS_406619531455_0/D
+ DVSS GF_NI_DVSS_BASE_0/comp018green_esd_clamp_v5p0_DVSS_0/pmos_6p0_CDNS_406619531455_0/D
+ GF_NI_DVSS_BASE_0/comp018green_esd_clamp_v5p0_DVSS_0/pmos_6p0_CDNS_406619531455_0/D
+ VDD GF_NI_DVSS_BASE_0/comp018green_esd_clamp_v5p0_DVSS_0/pmos_6p0_CDNS_406619531455_0/D
+ GF_NI_DVSS_BASE_0/comp018green_esd_clamp_v5p0_DVSS_0/pmos_6p0_CDNS_406619531455_0/D
+ DVDD GF_NI_DVSS_BASE_0/comp018green_esd_clamp_v5p0_DVSS_0/pmos_6p0_CDNS_406619531455_0/D
+ GF_NI_DVSS_BASE_0/comp018green_esd_clamp_v5p0_DVSS_0/pmos_6p0_CDNS_406619531455_0/D
+ GF_NI_DVSS_BASE_0/comp018green_esd_clamp_v5p0_DVSS_0/pmos_6p0_CDNS_406619531455_0/D
+ GF_NI_DVSS_BASE_0/comp018green_esd_clamp_v5p0_DVSS_0/pmos_6p0_CDNS_406619531455_0/D
+ GF_NI_DVSS_BASE_0/comp018green_esd_clamp_v5p0_DVSS_0/pmos_6p0_CDNS_406619531455_0/D
+ GF_NI_DVSS_BASE_0/comp018green_esd_clamp_v5p0_DVSS_0/pmos_6p0_CDNS_406619531455_0/D
+ GF_NI_DVSS_BASE_0/comp018green_esd_clamp_v5p0_DVSS_0/pmos_6p0_CDNS_406619531455_0/D
+ DVDD GF_NI_DVSS_BASE_0/comp018green_esd_clamp_v5p0_DVSS_0/pmos_6p0_CDNS_406619531455_0/D
+ GF_NI_DVSS_BASE_0/comp018green_esd_clamp_v5p0_DVSS_0/pmos_6p0_CDNS_406619531455_0/D
+ GF_NI_DVSS_BASE_0/comp018green_esd_clamp_v5p0_DVSS_0/pmos_6p0_CDNS_406619531455_0/D
+ GF_NI_DVSS_BASE_0/comp018green_esd_clamp_v5p0_DVSS_0/pmos_6p0_CDNS_406619531455_0/D
+ GF_NI_DVSS_BASE_0/comp018green_esd_clamp_v5p0_DVSS_0/pmos_6p0_CDNS_406619531452_0/D
+ GF_NI_DVSS_BASE_0/comp018green_esd_clamp_v5p0_DVSS_0/pmos_6p0_CDNS_406619531455_0/D
+ GF_NI_DVSS_BASE_0/comp018green_esd_clamp_v5p0_DVSS_0/pmos_6p0_CDNS_406619531455_0/D
+ GF_NI_DVSS_BASE_0/comp018green_esd_clamp_v5p0_DVSS_0/pmos_6p0_CDNS_406619531455_0/D
+ DVSS GF_NI_DVSS_BASE_0/comp018green_esd_clamp_v5p0_DVSS_0/pmos_6p0_CDNS_406619531455_0/D
+ GF_NI_DVSS_BASE_0/comp018green_esd_clamp_v5p0_DVSS_0/pmos_6p0_CDNS_406619531455_0/D
+ GF_NI_DVSS_BASE_0/comp018green_esd_clamp_v5p0_DVSS_0/pmos_6p0_CDNS_406619531455_0/D
+ DVDD DVSS GF_NI_DVSS_BASE_0/comp018green_esd_clamp_v5p0_DVSS_0/comp018green_esd_rc_v5p0_0/ppolyf_u_CDNS_406619531453_7/PLUS
+ GF_NI_DVSS_BASE_0/comp018green_esd_clamp_v5p0_DVSS_0/pmos_6p0_CDNS_406619531455_0/D
+ GF_NI_DVSS_BASE_0/comp018green_esd_clamp_v5p0_DVSS_0/pmos_6p0_CDNS_406619531452_0/D
+ GF_NI_DVSS_BASE_0/comp018green_esd_clamp_v5p0_DVSS_0/pmos_6p0_CDNS_406619531455_0/D
+ GF_NI_DVSS_BASE_0/comp018green_esd_clamp_v5p0_DVSS_0/pmos_6p0_CDNS_406619531455_0/D
+ GF_NI_DVSS_BASE_0/comp018green_esd_clamp_v5p0_DVSS_0/pmos_6p0_CDNS_406619531455_0/D
+ GF_NI_DVSS_BASE_0/comp018green_esd_clamp_v5p0_DVSS_0/pmos_6p0_CDNS_406619531455_0/D
+ DVSS GF_NI_DVSS_BASE_0/comp018green_esd_clamp_v5p0_DVSS_0/pmos_6p0_CDNS_406619531455_0/D
+ GF_NI_DVSS_BASE_0/comp018green_esd_clamp_v5p0_DVSS_0/pmos_6p0_CDNS_406619531455_0/D
+ GF_NI_DVSS_BASE_0/comp018green_esd_clamp_v5p0_DVSS_0/pmos_6p0_CDNS_406619531455_0/D
+ DVDD DVSS GF_NI_DVSS_BASE_0/comp018green_esd_clamp_v5p0_DVSS_0/pmos_6p0_CDNS_406619531455_0/D
+ GF_NI_DVSS_BASE_0/comp018green_esd_clamp_v5p0_DVSS_0/pmos_6p0_CDNS_406619531455_0/D
+ DVDD DVDD DVSS DVSS GF_NI_DVSS_BASE_0/comp018green_esd_clamp_v5p0_DVSS_0/pmos_6p0_CDNS_406619531455_0/D
+ DVSS GF_NI_DVSS_BASE_0/comp018green_esd_clamp_v5p0_DVSS_0/pmos_6p0_CDNS_406619531455_0/D
+ DVSS DVSS GF_NI_DVSS_BASE_0/comp018green_esd_clamp_v5p0_DVSS_0/pmos_6p0_CDNS_406619531455_0/D
+ GF_NI_DVSS_BASE_0/comp018green_esd_clamp_v5p0_DVSS_0/comp018green_esd_rc_v5p0_0/ppolyf_u_CDNS_406619531453_4/PLUS
+ GF_NI_DVSS_BASE_0/comp018green_esd_clamp_v5p0_DVSS_0/pmos_6p0_CDNS_406619531456_0/D
+ GF_NI_DVSS_BASE_0/comp018green_esd_clamp_v5p0_DVSS_0/pmos_6p0_CDNS_406619531456_0/D
+ DVSS DVDD GF_NI_DVSS_BASE_0/comp018green_esd_clamp_v5p0_DVSS_0/pmos_6p0_CDNS_406619531455_0/D
+ DVSS DVSS DVSS GF_NI_DVSS_BASE_0/comp018green_esd_clamp_v5p0_DVSS_0/pmos_6p0_CDNS_406619531456_0/D
+ GF_NI_DVSS_BASE_0/comp018green_esd_clamp_v5p0_DVSS_0/pmos_6p0_CDNS_406619531456_0/D
+ GF_NI_DVSS_BASE_0/comp018green_esd_clamp_v5p0_DVSS_0/pmos_6p0_CDNS_406619531456_0/D
+ GF_NI_DVSS_BASE_0/comp018green_esd_clamp_v5p0_DVSS_0/pmos_6p0_CDNS_406619531455_0/D
+ GF_NI_DVSS_BASE_0/comp018green_esd_clamp_v5p0_DVSS_0/pmos_6p0_CDNS_406619531456_0/D
+ DVSS GF_NI_DVSS_BASE_0/comp018green_esd_clamp_v5p0_DVSS_0/comp018green_esd_rc_v5p0_0/ppolyf_u_CDNS_406619531453_2/MINUS
+ GF_NI_DVSS_BASE_0/comp018green_esd_clamp_v5p0_DVSS_0/pmos_6p0_CDNS_406619531456_0/D
+ GF_NI_DVSS_BASE_0/comp018green_esd_clamp_v5p0_DVSS_0/pmos_6p0_CDNS_406619531456_0/D
+ GF_NI_DVSS_BASE_0/comp018green_esd_clamp_v5p0_DVSS_0/pmos_6p0_CDNS_406619531456_0/D
+ GF_NI_DVSS_BASE_0/comp018green_esd_clamp_v5p0_DVSS_0/pmos_6p0_CDNS_406619531455_0/D
+ DVDD GF_NI_DVSS_BASE_0/comp018green_esd_clamp_v5p0_DVSS_0/pmos_6p0_CDNS_406619531456_0/D
+ GF_NI_DVSS_BASE_0/comp018green_esd_clamp_v5p0_DVSS_0/pmos_6p0_CDNS_406619531456_0/D
+ GF_NI_DVSS_BASE_0/comp018green_esd_clamp_v5p0_DVSS_0/comp018green_esd_rc_v5p0_0/ppolyf_u_CDNS_406619531453_0/MINUS
+ VDD GF_NI_DVSS_BASE_0/comp018green_esd_clamp_v5p0_DVSS_0/comp018green_esd_rc_v5p0_0/ppolyf_u_CDNS_406619531453_1/PLUS
+ GF_NI_DVSS_BASE_0/comp018green_esd_clamp_v5p0_DVSS_0/pmos_6p0_CDNS_406619531455_0/D
+ GF_NI_DVSS_BASE_0/comp018green_esd_clamp_v5p0_DVSS_0/pmos_6p0_CDNS_406619531456_0/D
+ DVSS GF_NI_DVSS_BASE_0/comp018green_esd_clamp_v5p0_DVSS_0/pmos_6p0_CDNS_406619531456_0/D
+ DVSS GF_NI_DVSS_BASE_0/comp018green_esd_clamp_v5p0_DVSS_0/comp018green_esd_rc_v5p0_0/ppolyf_u_CDNS_406619531453_8/PLUS
+ DVDD GF_NI_DVSS_BASE_0/comp018green_esd_clamp_v5p0_DVSS_0/comp018green_esd_rc_v5p0_0/ppolyf_u_CDNS_406619531453_0/MINUS
+ DVDD GF_NI_DVSS_BASE_0/comp018green_esd_clamp_v5p0_DVSS_0/pmos_6p0_CDNS_406619531456_0/D
+ GF_NI_DVSS_BASE_0/comp018green_esd_clamp_v5p0_DVSS_0/pmos_6p0_CDNS_406619531455_0/D
+ GF_NI_DVSS_BASE_0/comp018green_esd_clamp_v5p0_DVSS_0/comp018green_esd_rc_v5p0_0/ppolyf_u_CDNS_406619531453_0/MINUS
+ DVDD DVSS GF_NI_DVSS_BASE_0/comp018green_esd_clamp_v5p0_DVSS_0/pmos_6p0_CDNS_406619531455_0/D
+ GF_NI_DVSS_BASE_0/comp018green_esd_clamp_v5p0_DVSS_0/comp018green_esd_rc_v5p0_0/ppolyf_u_CDNS_406619531453_2/MINUS
+ DVSS DVDD DVSS GF_NI_DVSS_BASE_0/comp018green_esd_clamp_v5p0_DVSS_0/comp018green_esd_rc_v5p0_0/ppolyf_u_CDNS_406619531453_3/MINUS
+ GF_NI_DVSS_BASE_0/comp018green_esd_clamp_v5p0_DVSS_0/pmos_6p0_CDNS_406619531452_0/D
+ GF_NI_DVSS_BASE_0/comp018green_esd_clamp_v5p0_DVSS_0/pmos_6p0_CDNS_406619531452_0/D
+ GF_NI_DVSS_BASE_0/comp018green_esd_clamp_v5p0_DVSS_0/pmos_6p0_CDNS_406619531456_0/D
+ GF_NI_DVSS_BASE_0/comp018green_esd_clamp_v5p0_DVSS_0/comp018green_esd_rc_v5p0_0/ppolyf_u_CDNS_406619531453_9/PLUS
+ DVDD DVSS DVDD GF_NI_DVSS_BASE_0/comp018green_esd_clamp_v5p0_DVSS_0/comp018green_esd_rc_v5p0_0/ppolyf_u_CDNS_406619531453_1/PLUS
+ GF_NI_DVSS_BASE_0/comp018green_esd_clamp_v5p0_DVSS_0/pmos_6p0_CDNS_406619531452_0/D
+ DVDD DVSS DVSS GF_NI_DVSS_BASE_0/comp018green_esd_clamp_v5p0_DVSS_0/comp018green_esd_rc_v5p0_0/ppolyf_u_CDNS_406619531453_8/PLUS
+ GF_NI_DVSS_BASE_0/comp018green_esd_clamp_v5p0_DVSS_0/comp018green_esd_rc_v5p0_0/ppolyf_u_CDNS_406619531453_7/PLUS
+ GF_NI_DVSS_BASE_0/comp018green_esd_clamp_v5p0_DVSS_0/pmos_6p0_CDNS_406619531455_0/D
+ DVSS GF_NI_DVSS_BASE_0/comp018green_esd_clamp_v5p0_DVSS_0/comp018green_esd_rc_v5p0_0/ppolyf_u_CDNS_406619531453_4/PLUS
+ GF_NI_DVSS_BASE_0/comp018green_esd_clamp_v5p0_DVSS_0/pmos_6p0_CDNS_406619531455_0/D
+ GF_NI_DVSS_BASE_0/comp018green_esd_clamp_v5p0_DVSS_0/pmos_6p0_CDNS_406619531456_0/D
+ GF_NI_DVSS_BASE_0/comp018green_esd_clamp_v5p0_DVSS_0/comp018green_esd_rc_v5p0_0/ppolyf_u_CDNS_406619531453_2/PLUS
+ GF_NI_DVSS_BASE_0/comp018green_esd_clamp_v5p0_DVSS_0/pmos_6p0_CDNS_406619531455_0/D
+ GF_NI_DVSS_BASE_0/comp018green_esd_clamp_v5p0_DVSS_0/pmos_6p0_CDNS_406619531456_0/D
+ DVSS DVSS GF_NI_DVSS_BASE_0/comp018green_esd_clamp_v5p0_DVSS_0/comp018green_esd_rc_v5p0_0/ppolyf_u_CDNS_406619531453_5/PLUS
+ GF_NI_DVSS_BASE_0/comp018green_esd_clamp_v5p0_DVSS_0/comp018green_esd_rc_v5p0_0/ppolyf_u_CDNS_406619531453_3/PLUS
+ DVSS DVDD GF_NI_DVSS_BASE_0/comp018green_esd_clamp_v5p0_DVSS_0/pmos_6p0_CDNS_406619531455_0/D
+ GF_NI_DVSS_BASE_0/comp018green_esd_clamp_v5p0_DVSS_0/pmos_6p0_CDNS_406619531455_0/D
+ DVSS GF_NI_DVSS_BASE_0/comp018green_esd_clamp_v5p0_DVSS_0/pmos_6p0_CDNS_406619531452_0/D
+ DVSS GF_NI_DVSS_BASE_0/comp018green_esd_clamp_v5p0_DVSS_0/comp018green_esd_rc_v5p0_0/ppolyf_u_CDNS_406619531453_0/PLUS
+ GF_NI_DVSS_BASE_0/comp018green_esd_clamp_v5p0_DVSS_0/pmos_6p0_CDNS_406619531455_0/D
+ GF_NI_DVSS_BASE_0/comp018green_esd_clamp_v5p0_DVSS_0/pmos_6p0_CDNS_406619531455_0/D
+ DVDD DVSS GF_NI_DVSS_BASE_0/comp018green_esd_clamp_v5p0_DVSS_0/pmos_6p0_CDNS_406619531455_0/D
+ GF_NI_DVSS_BASE_0/comp018green_esd_clamp_v5p0_DVSS_0/pmos_6p0_CDNS_406619531455_0/D
+ GF_NI_DVSS_BASE_0/comp018green_esd_clamp_v5p0_DVSS_0/pmos_6p0_CDNS_406619531452_0/D
+ GF_NI_DVSS_BASE_0/comp018green_esd_clamp_v5p0_DVSS_0/pmos_6p0_CDNS_406619531455_0/D
+ GF_NI_DVSS_BASE_0/comp018green_esd_clamp_v5p0_DVSS_0/pmos_6p0_CDNS_406619531455_0/D
+ DVSS GF_NI_DVSS_BASE_0/comp018green_esd_clamp_v5p0_DVSS_0/pmos_6p0_CDNS_406619531455_0/D
+ GF_NI_DVSS_BASE_0/comp018green_esd_clamp_v5p0_DVSS_0/pmos_6p0_CDNS_406619531455_0/D
+ GF_NI_DVSS_BASE_0/comp018green_esd_clamp_v5p0_DVSS_0/pmos_6p0_CDNS_406619531455_0/D
+ GF_NI_DVSS_BASE_0/comp018green_esd_clamp_v5p0_DVSS_0/comp018green_esd_rc_v5p0_0/ppolyf_u_CDNS_406619531453_2/PLUS
+ GF_NI_DVSS_BASE_0/comp018green_esd_clamp_v5p0_DVSS_0/comp018green_esd_rc_v5p0_0/ppolyf_u_CDNS_406619531453_5/PLUS
+ GF_NI_DVSS_BASE_0/comp018green_esd_clamp_v5p0_DVSS_0/pmos_6p0_CDNS_406619531455_0/D
+ GF_NI_DVSS_BASE_0/comp018green_esd_clamp_v5p0_DVSS_0/pmos_6p0_CDNS_406619531452_0/D
+ GF_NI_DVSS_BASE_0/comp018green_esd_clamp_v5p0_DVSS_0/pmos_6p0_CDNS_406619531455_0/D
+ GF_NI_DVSS_BASE_0/comp018green_esd_clamp_v5p0_DVSS_0/pmos_6p0_CDNS_406619531455_0/D
+ GF_NI_DVSS_BASE_0/comp018green_esd_clamp_v5p0_DVSS_0/pmos_6p0_CDNS_406619531455_0/D
+ GF_NI_DVSS_BASE_0/comp018green_esd_clamp_v5p0_DVSS_0/pmos_6p0_CDNS_406619531455_0/D
+ GF_NI_DVSS_BASE_0/comp018green_esd_clamp_v5p0_DVSS_0/pmos_6p0_CDNS_406619531455_0/D
+ GF_NI_DVSS_BASE_0/comp018green_esd_clamp_v5p0_DVSS_0/pmos_6p0_CDNS_406619531455_0/D
+ GF_NI_DVSS_BASE_0/comp018green_esd_clamp_v5p0_DVSS_0/pmos_6p0_CDNS_406619531456_0/D
+ GF_NI_DVSS_BASE_0/comp018green_esd_clamp_v5p0_DVSS_0/pmos_6p0_CDNS_406619531455_0/D
+ GF_NI_DVSS_BASE_0/comp018green_esd_clamp_v5p0_DVSS_0/pmos_6p0_CDNS_406619531455_0/D
+ DVDD GF_NI_DVSS_BASE_0/comp018green_esd_clamp_v5p0_DVSS_0/pmos_6p0_CDNS_406619531455_0/D
+ DVDD GF_NI_DVSS_BASE_0/comp018green_esd_clamp_v5p0_DVSS_0/pmos_6p0_CDNS_406619531455_0/D
+ DVSS GF_NI_DVSS_BASE_0/comp018green_esd_clamp_v5p0_DVSS_0/pmos_6p0_CDNS_406619531455_0/D
+ GF_NI_DVSS_BASE_0/comp018green_esd_clamp_v5p0_DVSS_0/pmos_6p0_CDNS_406619531455_0/D
+ DVDD DVSS GF_NI_DVSS_BASE_0/comp018green_esd_clamp_v5p0_DVSS_0/pmos_6p0_CDNS_406619531455_0/D
+ GF_NI_DVSS_BASE_0/comp018green_esd_clamp_v5p0_DVSS_0/pmos_6p0_CDNS_406619531455_0/D
+ DVSS GF_NI_DVSS_BASE_0/comp018green_esd_clamp_v5p0_DVSS_0/pmos_6p0_CDNS_406619531455_0/D
+ DVSS GF_NI_DVSS_BASE_0/comp018green_esd_clamp_v5p0_DVSS_0/pmos_6p0_CDNS_406619531455_0/D
+ GF_NI_DVSS_BASE_0/comp018green_esd_clamp_v5p0_DVSS_0/pmos_6p0_CDNS_406619531455_0/D
+ DVSS GF_NI_DVSS_BASE_0/comp018green_esd_clamp_v5p0_DVSS_0/pmos_6p0_CDNS_406619531455_0/D
+ DVDD GF_NI_DVSS_BASE_0/comp018green_esd_clamp_v5p0_DVSS_0/pmos_6p0_CDNS_406619531456_0/D
+ DVSS GF_NI_DVSS_BASE_0/comp018green_esd_clamp_v5p0_DVSS_0/pmos_6p0_CDNS_406619531455_0/D
+ GF_NI_DVSS_BASE_0/comp018green_esd_clamp_v5p0_DVSS_0/pmos_6p0_CDNS_406619531455_0/D
+ DVDD DVDD GF_NI_DVSS_BASE_0/comp018green_esd_clamp_v5p0_DVSS_0/pmos_6p0_CDNS_406619531455_0/D
+ GF_NI_DVSS_BASE_0/comp018green_esd_clamp_v5p0_DVSS_0/pmos_6p0_CDNS_406619531456_0/D
+ DVSS GF_NI_DVSS_BASE_0/comp018green_esd_clamp_v5p0_DVSS_0/pmos_6p0_CDNS_406619531455_0/D
+ GF_NI_DVSS_BASE_0/comp018green_esd_clamp_v5p0_DVSS_0/pmos_6p0_CDNS_406619531456_0/D
+ DVDD DVDD GF_NI_DVSS_BASE_0/comp018green_esd_clamp_v5p0_DVSS_0/pmos_6p0_CDNS_406619531455_0/D
+ GF_NI_DVSS_BASE_0/comp018green_esd_clamp_v5p0_DVSS_0/pmos_6p0_CDNS_406619531456_0/D
+ DVDD DVSS GF_NI_DVSS_BASE_0/comp018green_esd_clamp_v5p0_DVSS_0/pmos_6p0_CDNS_406619531456_0/D
+ GF_NI_DVSS_BASE_0/comp018green_esd_clamp_v5p0_DVSS_0/pmos_6p0_CDNS_406619531456_0/D
+ GF_NI_DVSS_BASE_0/comp018green_esd_clamp_v5p0_DVSS_0/pmos_6p0_CDNS_406619531455_0/D
+ DVDD GF_NI_DVSS_BASE_0/comp018green_esd_clamp_v5p0_DVSS_0/pmos_6p0_CDNS_406619531455_0/D
+ DVSS GF_NI_DVSS_BASE_0/comp018green_esd_clamp_v5p0_DVSS_0/pmos_6p0_CDNS_406619531455_0/D
+ DVSS GF_NI_DVSS_BASE_0/comp018green_esd_clamp_v5p0_DVSS_0/comp018green_esd_rc_v5p0_0/ppolyf_u_CDNS_406619531453_9/PLUS
+ GF_NI_DVSS_BASE_0/comp018green_esd_clamp_v5p0_DVSS_0/pmos_6p0_CDNS_406619531456_0/D
+ GF_NI_DVSS_BASE_0/comp018green_esd_clamp_v5p0_DVSS_0/pmos_6p0_CDNS_406619531456_0/D
+ DVDD DVDD DVDD GF_NI_DVSS_BASE_0/comp018green_esd_clamp_v5p0_DVSS_0/comp018green_esd_rc_v5p0_0/ppolyf_u_CDNS_406619531453_0/MINUS
+ GF_NI_DVSS_BASE_0/comp018green_esd_clamp_v5p0_DVSS_0/pmos_6p0_CDNS_406619531455_0/D
+ GF_NI_DVSS_BASE_0/comp018green_esd_clamp_v5p0_DVSS_0/pmos_6p0_CDNS_406619531456_0/D
+ DVSS GF_NI_DVSS_BASE_0/comp018green_esd_clamp_v5p0_DVSS_0/pmos_6p0_CDNS_406619531456_0/D
+ DVDD DVDD GF_NI_DVSS_BASE_0/comp018green_esd_clamp_v5p0_DVSS_0/pmos_6p0_CDNS_406619531455_0/D
+ DVDD DVDD DVDD DVSS GF_NI_DVSS_BASE_0/comp018green_esd_clamp_v5p0_DVSS_0/pmos_6p0_CDNS_406619531456_0/D
+ DVDD GF_NI_DVSS_BASE_0/comp018green_esd_clamp_v5p0_DVSS_0/pmos_6p0_CDNS_406619531452_0/D
+ DVDD DVSS DVSS DVDD DVDD DVSS GF_NI_DVSS_BASE_0/comp018green_esd_clamp_v5p0_DVSS_0/pmos_6p0_CDNS_406619531455_0/D
+ DVDD GF_NI_DVSS_BASE_0/comp018green_esd_clamp_v5p0_DVSS_0/comp018green_esd_rc_v5p0_0/ppolyf_u_CDNS_406619531453_0/MINUS
+ DVDD GF_NI_DVSS_BASE_0/comp018green_esd_clamp_v5p0_DVSS_0/pmos_6p0_CDNS_406619531455_0/D
+ GF_NI_DVSS_BASE_0/comp018green_esd_clamp_v5p0_DVSS_0/comp018green_esd_rc_v5p0_0/ppolyf_u_CDNS_406619531453_0/MINUS
+ GF_NI_DVSS_BASE_0/comp018green_esd_clamp_v5p0_DVSS_0/pmos_6p0_CDNS_406619531455_0/D
+ GF_NI_DVSS_BASE_0/comp018green_esd_clamp_v5p0_DVSS_0/pmos_6p0_CDNS_406619531455_0/D
+ GF_NI_DVSS_BASE_0/comp018green_esd_clamp_v5p0_DVSS_0/comp018green_esd_rc_v5p0_0/ppolyf_u_CDNS_406619531453_3/PLUS
+ GF_NI_DVSS_BASE_0/comp018green_esd_clamp_v5p0_DVSS_0/comp018green_esd_rc_v5p0_0/ppolyf_u_CDNS_406619531453_0/MINUS
+ DVSS DVSS DVDD DVSS GF_NI_DVSS_BASE_0/comp018green_esd_clamp_v5p0_DVSS_0/comp018green_esd_rc_v5p0_0/ppolyf_u_CDNS_406619531453_3/MINUS
+ DVSS DVDD DVSS DVSS DVSS DVDD DVSS DVSS DVSS DVDD DVDD GF_NI_DVSS_BASE_0/comp018green_esd_clamp_v5p0_DVSS_0/comp018green_esd_rc_v5p0_0/ppolyf_u_CDNS_406619531453_0/PLUS
+ GF_NI_DVSS_BASE
X0 DVDD DVSS cap_nmos_06v0 c_width=15u c_length=15u
X1 DVDD DVSS cap_nmos_06v0 c_width=15u c_length=15u
X2 DVDD DVSS cap_nmos_06v0 c_width=15u c_length=15u
X3 GF_NI_DVSS_BASE_0/comp018green_esd_clamp_v5p0_DVSS_0/comp018green_esd_rc_v5p0_0/ppolyf_u_CDNS_406619531453_0/MINUS DVSS cap_nmos_06v0 c_width=25u c_length=10u
X4 GF_NI_DVSS_BASE_0/comp018green_esd_clamp_v5p0_DVSS_0/comp018green_esd_rc_v5p0_0/ppolyf_u_CDNS_406619531453_0/MINUS DVSS cap_nmos_06v0 c_width=25u c_length=10u
X5 GF_NI_DVSS_BASE_0/comp018green_esd_clamp_v5p0_DVSS_0/comp018green_esd_rc_v5p0_0/ppolyf_u_CDNS_406619531453_0/MINUS DVSS cap_nmos_06v0 c_width=25u c_length=10u
X6 GF_NI_DVSS_BASE_0/comp018green_esd_clamp_v5p0_DVSS_0/comp018green_esd_rc_v5p0_0/ppolyf_u_CDNS_406619531453_0/MINUS DVSS cap_nmos_06v0 c_width=25u c_length=10u
X7 GF_NI_DVSS_BASE_0/comp018green_esd_clamp_v5p0_DVSS_0/comp018green_esd_rc_v5p0_0/ppolyf_u_CDNS_406619531453_0/MINUS DVSS cap_nmos_06v0 c_width=25u c_length=10u
X8 GF_NI_DVSS_BASE_0/comp018green_esd_clamp_v5p0_DVSS_0/comp018green_esd_rc_v5p0_0/ppolyf_u_CDNS_406619531453_0/MINUS DVSS cap_nmos_06v0 c_width=25u c_length=10u
X9 GF_NI_DVSS_BASE_0/comp018green_esd_clamp_v5p0_DVSS_0/comp018green_esd_rc_v5p0_0/ppolyf_u_CDNS_406619531453_0/MINUS DVSS cap_nmos_06v0 c_width=25u c_length=10u
X10 DVDD DVSS cap_nmos_06v0 c_width=15u c_length=15u
X11 GF_NI_DVSS_BASE_0/comp018green_esd_clamp_v5p0_DVSS_0/comp018green_esd_rc_v5p0_0/ppolyf_u_CDNS_406619531453_0/MINUS DVSS cap_nmos_06v0 c_width=25u c_length=10u
.ends

.subckt nmos_clamp_20_50_4_DVDD nmos_6p0_CDNS_406619531457_2/a_732_n44# nmos_6p0_CDNS_406619531457_3/a_0_n44#
+ nmos_6p0_CDNS_406619531457_2/a_976_n44# M2_M1_CDNS_40661953145136_6/m1_n92_n2414#
+ nmos_6p0_CDNS_406619531457_0/a_4636_n44# nmos_6p0_CDNS_406619531457_0/a_3660_n44#
+ M2_M1_CDNS_40661953145136_2/m1_n92_n2414# nmos_6p0_CDNS_406619531457_2/D nmos_6p0_CDNS_406619531457_1/a_3660_n44#
+ nmos_6p0_CDNS_406619531457_1/a_4636_n44# nmos_6p0_CDNS_406619531457_0/a_2440_n44#
+ nmos_6p0_CDNS_406619531457_0/a_3416_n44# nmos_6p0_CDNS_406619531457_3/a_732_n44#
+ nmos_6p0_CDNS_406619531457_2/a_3660_n44# nmos_6p0_CDNS_406619531457_2/a_4636_n44#
+ nmos_6p0_CDNS_406619531457_0/a_0_n44# nmos_6p0_CDNS_406619531457_0/a_2684_n44# nmos_6p0_CDNS_406619531457_1/a_2440_n44#
+ nmos_6p0_CDNS_406619531457_1/a_3416_n44# nmos_6p0_CDNS_406619531457_0/a_1220_n44#
+ nmos_6p0_CDNS_406619531457_3/a_976_n44# nmos_6p0_CDNS_406619531457_3/a_3660_n44#
+ nmos_6p0_CDNS_406619531457_3/a_4636_n44# nmos_6p0_CDNS_406619531457_1/a_2684_n44#
+ nmos_6p0_CDNS_406619531457_2/a_2440_n44# nmos_6p0_CDNS_406619531457_2/a_3416_n44#
+ nmos_6p0_CDNS_406619531457_0/a_1464_n44# nmos_6p0_CDNS_406619531457_1/a_1220_n44#
+ nmos_6p0_CDNS_406619531457_2/a_2684_n44# nmos_6p0_CDNS_406619531457_1/a_1464_n44#
+ nmos_6p0_CDNS_406619531457_3/a_2440_n44# nmos_6p0_CDNS_406619531457_3/a_3416_n44#
+ nmos_6p0_CDNS_406619531457_2/a_1220_n44# nmos_6p0_CDNS_406619531457_3/a_2684_n44#
+ nmos_6p0_CDNS_406619531457_2/a_1464_n44# nmos_6p0_CDNS_406619531457_3/a_1220_n44#
+ nmos_6p0_CDNS_406619531457_3/a_1464_n44# M2_M1_CDNS_40661953145136_7/m1_n92_n2414#
+ M2_M1_CDNS_40661953145136_0/m1_n92_n2414# nmos_6p0_CDNS_406619531457_0/a_244_n44#
+ nmos_6p0_CDNS_406619531457_0/a_488_n44# nmos_6p0_CDNS_406619531457_1/a_0_n44# M2_M1_CDNS_40661953145136_5/m1_n92_n2414#
+ M2_M1_CDNS_40661953145136_1/m1_n92_n2414# nmos_6p0_CDNS_406619531457_1/a_244_n44#
+ nmos_6p0_CDNS_406619531457_1/a_488_n44# nmos_6p0_CDNS_406619531457_0/a_3904_n44#
+ nmos_6p0_CDNS_406619531457_2/a_244_n44# nmos_6p0_CDNS_406619531457_1/a_3904_n44#
+ nmos_6p0_CDNS_406619531457_0/a_4392_n44# nmos_6p0_CDNS_406619531457_2/a_488_n44#
+ nmos_6p0_CDNS_406619531457_2/a_3904_n44# nmos_6p0_CDNS_406619531457_0/a_1952_n44#
+ nmos_6p0_CDNS_406619531457_0/a_2928_n44# nmos_6p0_CDNS_406619531457_1/a_4392_n44#
+ nmos_6p0_CDNS_406619531457_3/D nmos_6p0_CDNS_406619531457_0/a_3172_n44# nmos_6p0_CDNS_406619531457_0/a_4148_n44#
+ nmos_6p0_CDNS_406619531457_3/a_3904_n44# nmos_6p0_CDNS_406619531457_1/a_2928_n44#
+ nmos_6p0_CDNS_406619531457_1/a_1952_n44# nmos_6p0_CDNS_406619531457_2/a_4392_n44#
+ nmos_6p0_CDNS_406619531457_0/a_1708_n44# nmos_6p0_CDNS_406619531457_1/a_4148_n44#
+ nmos_6p0_CDNS_406619531457_1/a_3172_n44# nmos_6p0_CDNS_406619531457_2/a_1952_n44#
+ nmos_6p0_CDNS_406619531457_2/a_2928_n44# nmos_6p0_CDNS_406619531457_3/a_244_n44#
+ nmos_6p0_CDNS_406619531457_3/a_4392_n44# nmos_6p0_CDNS_406619531457_0/a_2196_n44#
+ nmos_6p0_CDNS_406619531457_1/a_1708_n44# nmos_6p0_CDNS_406619531457_2/a_4148_n44#
+ nmos_6p0_CDNS_406619531457_2/a_3172_n44# M2_M1_CDNS_40661953145136_4/m1_n92_n2414#
+ nmos_6p0_CDNS_406619531457_3/a_488_n44# nmos_6p0_CDNS_406619531457_3/a_1952_n44#
+ nmos_6p0_CDNS_406619531457_3/a_2928_n44# nmos_6p0_CDNS_406619531457_2/a_1708_n44#
+ nmos_6p0_CDNS_406619531457_1/a_2196_n44# nmos_6p0_CDNS_406619531457_3/a_3172_n44#
+ nmos_6p0_CDNS_406619531457_3/a_4148_n44# nmos_6p0_CDNS_406619531457_3/a_1708_n44#
+ nmos_6p0_CDNS_406619531457_2/a_2196_n44# nmos_6p0_CDNS_406619531457_2/a_0_n44# nmos_6p0_CDNS_406619531457_3/a_2196_n44#
+ nmos_6p0_CDNS_406619531457_1/S nmos_6p0_CDNS_406619531457_0/a_732_n44# nmos_6p0_CDNS_406619531457_0/a_976_n44#
+ M2_M1_CDNS_40661953145136_3/m1_n92_n2414# nmos_6p0_CDNS_406619531457_1/D nmos_6p0_CDNS_406619531457_1/a_732_n44#
+ nmos_6p0_CDNS_406619531457_1/a_976_n44# nmos_6p0_CDNS_406619531457_0/S nmos_6p0_CDNS_406619531457_0/D
+ nmos_6p0_CDNS_406619531457_2/S VSUBS nmos_6p0_CDNS_406619531457_3/S M2_M1_CDNS_40661953145139_3/m1_n308_n146#
Xnmos_6p0_CDNS_406619531457_0 nmos_6p0_CDNS_406619531457_0/D nmos_6p0_CDNS_406619531457_0/a_3904_n44#
+ nmos_6p0_CDNS_406619531457_0/a_4392_n44# nmos_6p0_CDNS_406619531457_0/a_2928_n44#
+ nmos_6p0_CDNS_406619531457_0/a_1952_n44# nmos_6p0_CDNS_406619531457_0/a_4148_n44#
+ nmos_6p0_CDNS_406619531457_0/a_3172_n44# nmos_6p0_CDNS_406619531457_0/a_1708_n44#
+ nmos_6p0_CDNS_406619531457_0/a_2196_n44# nmos_6p0_CDNS_406619531457_0/a_732_n44#
+ nmos_6p0_CDNS_406619531457_0/a_976_n44# nmos_6p0_CDNS_406619531457_0/a_0_n44# nmos_6p0_CDNS_406619531457_0/S
+ nmos_6p0_CDNS_406619531457_0/a_4636_n44# nmos_6p0_CDNS_406619531457_0/a_3660_n44#
+ nmos_6p0_CDNS_406619531457_0/a_3416_n44# nmos_6p0_CDNS_406619531457_0/a_2440_n44#
+ nmos_6p0_CDNS_406619531457_0/a_2684_n44# nmos_6p0_CDNS_406619531457_0/a_1220_n44#
+ nmos_6p0_CDNS_406619531457_0/a_1464_n44# nmos_6p0_CDNS_406619531457_0/a_244_n44#
+ nmos_6p0_CDNS_406619531457_0/a_488_n44# VSUBS nmos_6p0_CDNS_406619531457
Xnmos_6p0_CDNS_406619531457_1 nmos_6p0_CDNS_406619531457_1/D nmos_6p0_CDNS_406619531457_1/a_3904_n44#
+ nmos_6p0_CDNS_406619531457_1/a_4392_n44# nmos_6p0_CDNS_406619531457_1/a_2928_n44#
+ nmos_6p0_CDNS_406619531457_1/a_1952_n44# nmos_6p0_CDNS_406619531457_1/a_4148_n44#
+ nmos_6p0_CDNS_406619531457_1/a_3172_n44# nmos_6p0_CDNS_406619531457_1/a_1708_n44#
+ nmos_6p0_CDNS_406619531457_1/a_2196_n44# nmos_6p0_CDNS_406619531457_1/a_732_n44#
+ nmos_6p0_CDNS_406619531457_1/a_976_n44# nmos_6p0_CDNS_406619531457_1/a_0_n44# nmos_6p0_CDNS_406619531457_1/S
+ nmos_6p0_CDNS_406619531457_1/a_4636_n44# nmos_6p0_CDNS_406619531457_1/a_3660_n44#
+ nmos_6p0_CDNS_406619531457_1/a_3416_n44# nmos_6p0_CDNS_406619531457_1/a_2440_n44#
+ nmos_6p0_CDNS_406619531457_1/a_2684_n44# nmos_6p0_CDNS_406619531457_1/a_1220_n44#
+ nmos_6p0_CDNS_406619531457_1/a_1464_n44# nmos_6p0_CDNS_406619531457_1/a_244_n44#
+ nmos_6p0_CDNS_406619531457_1/a_488_n44# VSUBS nmos_6p0_CDNS_406619531457
Xnmos_6p0_CDNS_406619531457_2 nmos_6p0_CDNS_406619531457_2/D nmos_6p0_CDNS_406619531457_2/a_3904_n44#
+ nmos_6p0_CDNS_406619531457_2/a_4392_n44# nmos_6p0_CDNS_406619531457_2/a_2928_n44#
+ nmos_6p0_CDNS_406619531457_2/a_1952_n44# nmos_6p0_CDNS_406619531457_2/a_4148_n44#
+ nmos_6p0_CDNS_406619531457_2/a_3172_n44# nmos_6p0_CDNS_406619531457_2/a_1708_n44#
+ nmos_6p0_CDNS_406619531457_2/a_2196_n44# nmos_6p0_CDNS_406619531457_2/a_732_n44#
+ nmos_6p0_CDNS_406619531457_2/a_976_n44# nmos_6p0_CDNS_406619531457_2/a_0_n44# nmos_6p0_CDNS_406619531457_2/S
+ nmos_6p0_CDNS_406619531457_2/a_4636_n44# nmos_6p0_CDNS_406619531457_2/a_3660_n44#
+ nmos_6p0_CDNS_406619531457_2/a_3416_n44# nmos_6p0_CDNS_406619531457_2/a_2440_n44#
+ nmos_6p0_CDNS_406619531457_2/a_2684_n44# nmos_6p0_CDNS_406619531457_2/a_1220_n44#
+ nmos_6p0_CDNS_406619531457_2/a_1464_n44# nmos_6p0_CDNS_406619531457_2/a_244_n44#
+ nmos_6p0_CDNS_406619531457_2/a_488_n44# VSUBS nmos_6p0_CDNS_406619531457
Xnmos_6p0_CDNS_406619531457_3 nmos_6p0_CDNS_406619531457_3/D nmos_6p0_CDNS_406619531457_3/a_3904_n44#
+ nmos_6p0_CDNS_406619531457_3/a_4392_n44# nmos_6p0_CDNS_406619531457_3/a_2928_n44#
+ nmos_6p0_CDNS_406619531457_3/a_1952_n44# nmos_6p0_CDNS_406619531457_3/a_4148_n44#
+ nmos_6p0_CDNS_406619531457_3/a_3172_n44# nmos_6p0_CDNS_406619531457_3/a_1708_n44#
+ nmos_6p0_CDNS_406619531457_3/a_2196_n44# nmos_6p0_CDNS_406619531457_3/a_732_n44#
+ nmos_6p0_CDNS_406619531457_3/a_976_n44# nmos_6p0_CDNS_406619531457_3/a_0_n44# nmos_6p0_CDNS_406619531457_3/S
+ nmos_6p0_CDNS_406619531457_3/a_4636_n44# nmos_6p0_CDNS_406619531457_3/a_3660_n44#
+ nmos_6p0_CDNS_406619531457_3/a_3416_n44# nmos_6p0_CDNS_406619531457_3/a_2440_n44#
+ nmos_6p0_CDNS_406619531457_3/a_2684_n44# nmos_6p0_CDNS_406619531457_3/a_1220_n44#
+ nmos_6p0_CDNS_406619531457_3/a_1464_n44# nmos_6p0_CDNS_406619531457_3/a_244_n44#
+ nmos_6p0_CDNS_406619531457_3/a_488_n44# VSUBS nmos_6p0_CDNS_406619531457
.ends

.subckt comp018green_esd_clamp_v5p0_DVDD M2_M1_CDNS_40661953145117_5/m1_n90_n38# pmos_6p0_CDNS_406619531452_0/a_244_n44#
+ nmos_clamp_20_50_4_DVDD_0/M2_M1_CDNS_40661953145136_4/m1_n92_n2414# pmos_6p0_CDNS_406619531452_0/D
+ nmos_clamp_20_50_4_DVDD_0/nmos_6p0_CDNS_406619531457_3/a_732_n44# pmos_6p0_CDNS_406619531452_0/a_488_n44#
+ nmos_clamp_20_50_4_DVDD_0/nmos_6p0_CDNS_406619531457_3/a_976_n44# comp018green_esd_rc_v5p0_0/ppolyf_u_CDNS_406619531453_8/PLUS
+ M1_POLY2_CDNS_40661953145106_0/a_n89_n42# nmos_clamp_20_50_4_DVDD_0/nmos_6p0_CDNS_406619531457_2/D
+ comp018green_esd_rc_v5p0_0/ppolyf_u_CDNS_406619531453_10/PLUS comp018green_esd_rc_v5p0_0/ppolyf_u_CDNS_406619531453_5/PLUS
+ M2_M1_CDNS_40661953145112_0/m1_n246_n38# pmos_6p0_CDNS_406619531455_0/a_5612_n44#
+ nmos_clamp_20_50_4_DVDD_0/nmos_6p0_CDNS_406619531457_0/a_3904_n44# nmos_6p0_CDNS_406619531459_0/S
+ nmos_6p0_CDNS_406619531458_0/a_244_n44# M2_M1_CDNS_40661953145118_4/m1_n974_n38#
+ pmos_6p0_CDNS_406619531455_0/a_4880_n44# pmos_6p0_CDNS_406619531456_0/a_244_n44#
+ nmos_clamp_20_50_4_DVDD_0/nmos_6p0_CDNS_406619531457_1/a_3904_n44# nmos_6p0_CDNS_406619531458_0/a_488_n44#
+ nmos_clamp_20_50_4_DVDD_0/nmos_6p0_CDNS_406619531457_0/a_4392_n44# comp018green_esd_rc_v5p0_0/ppolyf_u_CDNS_406619531453_2/PLUS
+ nmos_clamp_20_50_4_DVDD_0/nmos_6p0_CDNS_406619531457_2/a_0_n44# nmos_6p0_CDNS_406619531458_0/a_0_n44#
+ pmos_6p0_CDNS_406619531456_0/a_488_n44# nmos_clamp_20_50_4_DVDD_0/nmos_6p0_CDNS_406619531457_2/a_3904_n44#
+ pmos_6p0_CDNS_406619531455_0/a_3660_n44# nmos_clamp_20_50_4_DVDD_0/nmos_6p0_CDNS_406619531457_0/a_2928_n44#
+ nmos_clamp_20_50_4_DVDD_0/nmos_6p0_CDNS_406619531457_0/a_1952_n44# nmos_clamp_20_50_4_DVDD_0/M2_M1_CDNS_40661953145136_3/m1_n92_n2414#
+ pmos_6p0_CDNS_406619531455_0/a_4636_n44# nmos_clamp_20_50_4_DVDD_0/nmos_6p0_CDNS_406619531457_1/a_4392_n44#
+ nmos_clamp_20_50_4_DVDD_0/nmos_6p0_CDNS_406619531457_0/a_3172_n44# nmos_clamp_20_50_4_DVDD_0/nmos_6p0_CDNS_406619531457_0/a_4148_n44#
+ nmos_clamp_20_50_4_DVDD_0/nmos_6p0_CDNS_406619531457_3/a_3904_n44# nmos_clamp_20_50_4_DVDD_0/nmos_6p0_CDNS_406619531457_1/a_1952_n44#
+ nmos_clamp_20_50_4_DVDD_0/nmos_6p0_CDNS_406619531457_1/a_2928_n44# nmos_clamp_20_50_4_DVDD_0/nmos_6p0_CDNS_406619531457_2/a_4392_n44#
+ pmos_6p0_CDNS_406619531456_0/D pmos_6p0_CDNS_406619531455_0/a_3416_n44# pmos_6p0_CDNS_406619531455_0/a_2440_n44#
+ nmos_clamp_20_50_4_DVDD_0/nmos_6p0_CDNS_406619531457_0/a_1708_n44# nmos_clamp_20_50_4_DVDD_0/nmos_6p0_CDNS_406619531457_1/a_3172_n44#
+ nmos_clamp_20_50_4_DVDD_0/nmos_6p0_CDNS_406619531457_1/a_4148_n44# nmos_clamp_20_50_4_DVDD_0/nmos_6p0_CDNS_406619531457_2/a_2928_n44#
+ nmos_clamp_20_50_4_DVDD_0/nmos_6p0_CDNS_406619531457_2/a_1952_n44# M1_POLY2_CDNS_40661953145110_0/a_n2862_n42#
+ nmos_6p0_CDNS_406619531458_1/a_244_n44# nmos_clamp_20_50_4_DVDD_0/nmos_6p0_CDNS_406619531457_3/a_4392_n44#
+ pmos_6p0_CDNS_406619531455_0/a_2684_n44# pmos_6p0_CDNS_406619531455_0/a_0_n44# nmos_clamp_20_50_4_DVDD_0/nmos_6p0_CDNS_406619531457_1/a_1708_n44#
+ nmos_clamp_20_50_4_DVDD_0/nmos_6p0_CDNS_406619531457_2/a_3172_n44# nmos_clamp_20_50_4_DVDD_0/nmos_6p0_CDNS_406619531457_2/a_4148_n44#
+ pmos_6p0_CDNS_406619531455_0/a_1220_n44# nmos_clamp_20_50_4_DVDD_0/nmos_6p0_CDNS_406619531457_0/a_2196_n44#
+ nmos_6p0_CDNS_406619531458_0/D nmos_6p0_CDNS_406619531458_1/a_488_n44# nmos_clamp_20_50_4_DVDD_0/nmos_6p0_CDNS_406619531457_3/a_2928_n44#
+ nmos_clamp_20_50_4_DVDD_0/nmos_6p0_CDNS_406619531457_3/a_1952_n44# nmos_clamp_20_50_4_DVDD_0/nmos_6p0_CDNS_406619531457_0/a_244_n44#
+ nmos_clamp_20_50_4_DVDD_0/nmos_6p0_CDNS_406619531457_2/a_1708_n44# nmos_clamp_20_50_4_DVDD_0/nmos_6p0_CDNS_406619531457_3/a_4148_n44#
+ nmos_clamp_20_50_4_DVDD_0/nmos_6p0_CDNS_406619531457_3/a_3172_n44# pmos_6p0_CDNS_406619531455_0/a_1464_n44#
+ nmos_clamp_20_50_4_DVDD_0/nmos_6p0_CDNS_406619531457_1/a_2196_n44# nmos_6p0_CDNS_406619531459_0/a_0_n44#
+ M1_POLY2_CDNS_40661953145109_0/a_n653_n42# nmos_clamp_20_50_4_DVDD_0/nmos_6p0_CDNS_406619531457_0/a_488_n44#
+ nmos_clamp_20_50_4_DVDD_0/nmos_6p0_CDNS_406619531457_3/a_1708_n44# nmos_clamp_20_50_4_DVDD_0/nmos_6p0_CDNS_406619531457_2/a_2196_n44#
+ M1_POLY2_CDNS_40661953145109_1/a_n653_n42# nmos_clamp_20_50_4_DVDD_0/nmos_6p0_CDNS_406619531457_3/a_2196_n44#
+ pmos_6p0_CDNS_406619531456_0/a_0_n44# comp018green_esd_rc_v5p0_0/ppolyf_u_CDNS_406619531453_9/PLUS
+ nmos_clamp_20_50_4_DVDD_0/nmos_6p0_CDNS_406619531457_1/a_244_n44# pmos_6p0_CDNS_406619531455_0/a_244_n44#
+ nmos_clamp_20_50_4_DVDD_0/M2_M1_CDNS_40661953145136_6/m1_n92_n2414# nmos_clamp_20_50_4_DVDD_0/nmos_6p0_CDNS_406619531457_1/a_488_n44#
+ pmos_6p0_CDNS_406619531455_0/a_488_n44# nmos_clamp_20_50_4_DVDD_0/M2_M1_CDNS_40661953145136_2/m1_n92_n2414#
+ comp018green_esd_rc_v5p0_0/ppolyf_u_CDNS_406619531453_11/PLUS comp018green_esd_rc_v5p0_0/ppolyf_u_CDNS_406619531453_6/PLUS
+ comp018green_esd_rc_v5p0_0/ppolyf_u_CDNS_406619531453_0/MINUS pmos_6p0_CDNS_406619531452_0/a_732_n44#
+ nmos_clamp_20_50_4_DVDD_0/nmos_6p0_CDNS_406619531457_2/a_244_n44# comp018green_esd_rc_v5p0_0/ppolyf_u_CDNS_406619531453_1/MINUS
+ M2_M1_CDNS_40661953145113_0/m1_n454_n38# nmos_clamp_20_50_4_DVDD_0/nmos_6p0_CDNS_406619531457_2/a_488_n44#
+ nmos_6p0_CDNS_406619531458_0/a_1220_n44# nmos_clamp_20_50_4_DVDD_0/nmos_6p0_CDNS_406619531457_3/a_0_n44#
+ comp018green_esd_rc_v5p0_0/ppolyf_u_CDNS_406619531453_3/PLUS nmos_6p0_CDNS_406619531458_1/a_0_n44#
+ comp018green_esd_rc_v5p0_0/ppolyf_u_CDNS_406619531453_2/MINUS nmos_6p0_CDNS_406619531458_1/a_1220_n44#
+ comp018green_esd_rc_v5p0_0/ppolyf_u_CDNS_406619531453_3/MINUS nmos_clamp_20_50_4_DVDD_0/nmos_6p0_CDNS_406619531457_3/a_244_n44#
+ comp018green_esd_rc_v5p0_0/ppolyf_u_CDNS_406619531453_0/PLUS nmos_clamp_20_50_4_DVDD_0/nmos_6p0_CDNS_406619531457_3/a_488_n44#
+ nmos_6p0_CDNS_406619531459_0/D comp018green_esd_rc_v5p0_0/ppolyf_u_CDNS_406619531453_4/MINUS
+ M2_M1_CDNS_40661953145118_2/m1_n974_n38# comp018green_esd_rc_v5p0_0/ppolyf_u_CDNS_406619531453_10/MINUS
+ nmos_clamp_20_50_4_DVDD_0/M2_M1_CDNS_40661953145136_7/m1_n92_n2414# nmos_clamp_20_50_4_DVDD_0/nmos_6p0_CDNS_406619531457_0/a_0_n44#
+ comp018green_esd_rc_v5p0_0/ppolyf_u_CDNS_406619531453_5/MINUS nmos_clamp_20_50_4_DVDD_0/M2_M1_CDNS_40661953145136_0/m1_n92_n2414#
+ nmos_6p0_CDNS_406619531458_0/a_732_n44# comp018green_esd_rc_v5p0_0/ppolyf_u_CDNS_406619531453_11/MINUS
+ nmos_6p0_CDNS_406619531458_0/a_976_n44# nmos_clamp_20_50_4_DVDD_0/nmos_6p0_CDNS_406619531457_3/D
+ comp018green_esd_rc_v5p0_0/ppolyf_u_CDNS_406619531453_6/MINUS nmos_clamp_20_50_4_DVDD_0/nmos_6p0_CDNS_406619531457_0/a_3660_n44#
+ nmos_clamp_20_50_4_DVDD_0/nmos_6p0_CDNS_406619531457_0/a_4636_n44# comp018green_esd_rc_v5p0_0/ppolyf_u_CDNS_406619531453_7/MINUS
+ pmos_6p0_CDNS_406619531455_0/a_3904_n44# nmos_clamp_20_50_4_DVDD_0/nmos_6p0_CDNS_406619531457_1/a_4636_n44#
+ nmos_clamp_20_50_4_DVDD_0/nmos_6p0_CDNS_406619531457_1/a_3660_n44# pmos_6p0_CDNS_406619531455_0/a_5124_n44#
+ nmos_clamp_20_50_4_DVDD_0/nmos_6p0_CDNS_406619531457_0/a_3416_n44# nmos_clamp_20_50_4_DVDD_0/nmos_6p0_CDNS_406619531457_0/a_2440_n44#
+ nmos_6p0_CDNS_406619531458_1/a_732_n44# nmos_clamp_20_50_4_DVDD_0/nmos_6p0_CDNS_406619531457_2/a_3660_n44#
+ comp018green_esd_rc_v5p0_0/ppolyf_u_CDNS_406619531453_8/MINUS nmos_clamp_20_50_4_DVDD_0/nmos_6p0_CDNS_406619531457_2/a_4636_n44#
+ pmos_6p0_CDNS_406619531455_0/a_5368_n44# pmos_6p0_CDNS_406619531455_0/a_4392_n44#
+ nmos_clamp_20_50_4_DVDD_0/nmos_6p0_CDNS_406619531457_0/a_2684_n44# nmos_clamp_20_50_4_DVDD_0/nmos_6p0_CDNS_406619531457_1/a_3416_n44#
+ nmos_clamp_20_50_4_DVDD_0/nmos_6p0_CDNS_406619531457_1/a_2440_n44# nmos_6p0_CDNS_406619531458_1/a_976_n44#
+ comp018green_esd_rc_v5p0_0/ppolyf_u_CDNS_406619531453_7/PLUS nmos_clamp_20_50_4_DVDD_0/nmos_6p0_CDNS_406619531457_0/a_1220_n44#
+ nmos_clamp_20_50_4_DVDD_0/nmos_6p0_CDNS_406619531457_0/a_732_n44# nmos_clamp_20_50_4_DVDD_0/nmos_6p0_CDNS_406619531457_3/a_4636_n44#
+ nmos_clamp_20_50_4_DVDD_0/nmos_6p0_CDNS_406619531457_3/a_3660_n44# pmos_6p0_CDNS_406619531455_0/a_1952_n44#
+ pmos_6p0_CDNS_406619531455_0/a_2928_n44# nmos_clamp_20_50_4_DVDD_0/nmos_6p0_CDNS_406619531457_1/a_2684_n44#
+ nmos_clamp_20_50_4_DVDD_0/nmos_6p0_CDNS_406619531457_2/a_3416_n44# nmos_clamp_20_50_4_DVDD_0/nmos_6p0_CDNS_406619531457_2/a_2440_n44#
+ pmos_6p0_CDNS_406619531455_0/a_4148_n44# pmos_6p0_CDNS_406619531455_0/a_3172_n44#
+ nmos_clamp_20_50_4_DVDD_0/nmos_6p0_CDNS_406619531457_0/D nmos_clamp_20_50_4_DVDD_0/nmos_6p0_CDNS_406619531457_0/a_1464_n44#
+ nmos_clamp_20_50_4_DVDD_0/nmos_6p0_CDNS_406619531457_1/a_1220_n44# comp018green_esd_rc_v5p0_0/ppolyf_u_CDNS_406619531453_9/MINUS
+ nmos_clamp_20_50_4_DVDD_0/nmos_6p0_CDNS_406619531457_0/a_976_n44# M2_M1_CDNS_40661953145118_6/m1_n974_n38#
+ nmos_clamp_20_50_4_DVDD_0/nmos_6p0_CDNS_406619531457_2/a_2684_n44# nmos_clamp_20_50_4_DVDD_0/nmos_6p0_CDNS_406619531457_3/a_3416_n44#
+ nmos_clamp_20_50_4_DVDD_0/nmos_6p0_CDNS_406619531457_3/a_2440_n44# pmos_6p0_CDNS_406619531455_0/a_1708_n44#
+ nmos_clamp_20_50_4_DVDD_0/nmos_6p0_CDNS_406619531457_1/a_1464_n44# nmos_clamp_20_50_4_DVDD_0/nmos_6p0_CDNS_406619531457_2/a_1220_n44#
+ M2_M1_CDNS_40661953145118_1/m1_n974_n38# nmos_clamp_20_50_4_DVDD_0/nmos_6p0_CDNS_406619531457_3/a_2684_n44#
+ nmos_clamp_20_50_4_DVDD_0/nmos_6p0_CDNS_406619531457_2/a_1464_n44# nmos_clamp_20_50_4_DVDD_0/nmos_6p0_CDNS_406619531457_3/a_1220_n44#
+ nmos_clamp_20_50_4_DVDD_0/M2_M1_CDNS_40661953145136_5/m1_n92_n2414# pmos_6p0_CDNS_406619531455_0/a_2196_n44#
+ comp018green_esd_rc_v5p0_0/ppolyf_u_CDNS_406619531453_4/PLUS M1_POLY2_CDNS_40661953145105_0/a_n371_n42#
+ M2_M1_CDNS_40661953145114_1/m1_n610_n38# nmos_6p0_CDNS_406619531458_1/D nmos_clamp_20_50_4_DVDD_0/M2_M1_CDNS_40661953145136_1/m1_n92_n2414#
+ nmos_clamp_20_50_4_DVDD_0/nmos_6p0_CDNS_406619531457_3/a_1464_n44# nmos_clamp_20_50_4_DVDD_0/nmos_6p0_CDNS_406619531457_0/S
+ nmos_clamp_20_50_4_DVDD_0/nmos_6p0_CDNS_406619531457_1/a_732_n44# pmos_6p0_CDNS_406619531455_0/a_732_n44#
+ nmos_clamp_20_50_4_DVDD_0/nmos_6p0_CDNS_406619531457_1/a_976_n44# M2_M1_CDNS_40661953145103_0/m1_n92_n92#
+ nmos_6p0_CDNS_406619531458_1/S pmos_6p0_CDNS_406619531455_0/a_976_n44# nmos_clamp_20_50_4_DVDD_0/nmos_6p0_CDNS_406619531457_1/S
+ M2_M1_CDNS_40661953145103_1/m1_n92_n92# M2_M1_CDNS_40661953145117_0/m1_n90_n38#
+ comp018green_esd_rc_v5p0_0/ppolyf_u_CDNS_406619531453_1/PLUS nmos_clamp_20_50_4_DVDD_0/M2_M1_CDNS_40661953145139_3/m1_n308_n146#
+ nmos_clamp_20_50_4_DVDD_0/nmos_6p0_CDNS_406619531457_1/a_0_n44# M2_M1_CDNS_40661953145117_1/m1_n90_n38#
+ nmos_clamp_20_50_4_DVDD_0/nmos_6p0_CDNS_406619531457_2/a_732_n44# M2_M1_CDNS_40661953145117_2/m1_n90_n38#
+ pmos_6p0_CDNS_406619531455_0/D nmos_clamp_20_50_4_DVDD_0/nmos_6p0_CDNS_406619531457_2/a_976_n44#
+ pmos_6p0_CDNS_406619531456_0/S M1_POLY2_CDNS_40661953145108_0/a_n277_n42# nmos_clamp_20_50_4_DVDD_0/nmos_6p0_CDNS_406619531457_3/S
+ nmos_clamp_20_50_4_DVDD_0/nmos_6p0_CDNS_406619531457_2/S VSUBS nmos_clamp_20_50_4_DVDD_0/nmos_6p0_CDNS_406619531457_1/D
+ pmos_6p0_CDNS_406619531452_0/a_0_n44# M2_M1_CDNS_40661953145118_7/m1_n974_n38#
Xpmos_6p0_CDNS_406619531455_0 pmos_6p0_CDNS_406619531456_0/S pmos_6p0_CDNS_406619531455_0/D
+ pmos_6p0_CDNS_406619531455_0/a_5124_n44# pmos_6p0_CDNS_406619531455_0/a_3904_n44#
+ pmos_6p0_CDNS_406619531455_0/a_5368_n44# pmos_6p0_CDNS_406619531455_0/a_4392_n44#
+ pmos_6p0_CDNS_406619531455_0/a_2928_n44# pmos_6p0_CDNS_406619531455_0/a_1952_n44#
+ pmos_6p0_CDNS_406619531455_0/a_4148_n44# pmos_6p0_CDNS_406619531455_0/a_3172_n44#
+ pmos_6p0_CDNS_406619531455_0/a_1708_n44# pmos_6p0_CDNS_406619531455_0/a_2196_n44#
+ pmos_6p0_CDNS_406619531455_0/a_732_n44# pmos_6p0_CDNS_406619531455_0/a_976_n44#
+ pmos_6p0_CDNS_406619531455_0/a_0_n44# pmos_6p0_CDNS_406619531455_0/a_5612_n44# pmos_6p0_CDNS_406619531455_0/a_4880_n44#
+ pmos_6p0_CDNS_406619531456_0/S pmos_6p0_CDNS_406619531455_0/a_4636_n44# pmos_6p0_CDNS_406619531455_0/a_3660_n44#
+ pmos_6p0_CDNS_406619531455_0/a_3416_n44# pmos_6p0_CDNS_406619531455_0/a_2440_n44#
+ pmos_6p0_CDNS_406619531455_0/a_2684_n44# pmos_6p0_CDNS_406619531455_0/a_1220_n44#
+ pmos_6p0_CDNS_406619531455_0/a_1464_n44# pmos_6p0_CDNS_406619531455_0/a_244_n44#
+ pmos_6p0_CDNS_406619531455_0/a_488_n44# pmos_6p0_CDNS_406619531455
Xnmos_6p0_CDNS_406619531459_0 nmos_6p0_CDNS_406619531459_0/D nmos_6p0_CDNS_406619531459_0/a_0_n44#
+ nmos_6p0_CDNS_406619531459_0/S VSUBS nmos_6p0_CDNS_406619531459
Xpmos_6p0_CDNS_406619531456_0 pmos_6p0_CDNS_406619531456_0/S pmos_6p0_CDNS_406619531456_0/D
+ pmos_6p0_CDNS_406619531456_0/a_0_n44# pmos_6p0_CDNS_406619531456_0/S pmos_6p0_CDNS_406619531456_0/a_244_n44#
+ pmos_6p0_CDNS_406619531456_0/a_488_n44# pmos_6p0_CDNS_406619531456
Xcomp018green_esd_rc_v5p0_0 comp018green_esd_rc_v5p0_0/ppolyf_u_CDNS_406619531453_10/MINUS
+ comp018green_esd_rc_v5p0_0/ppolyf_u_CDNS_406619531453_3/PLUS comp018green_esd_rc_v5p0_0/ppolyf_u_CDNS_406619531453_11/MINUS
+ comp018green_esd_rc_v5p0_0/ppolyf_u_CDNS_406619531453_0/PLUS comp018green_esd_rc_v5p0_0/ppolyf_u_CDNS_406619531453_11/PLUS
+ comp018green_esd_rc_v5p0_0/ppolyf_u_CDNS_406619531453_0/MINUS comp018green_esd_rc_v5p0_0/ppolyf_u_CDNS_406619531453_7/PLUS
+ comp018green_esd_rc_v5p0_0/ppolyf_u_CDNS_406619531453_1/MINUS comp018green_esd_rc_v5p0_0/ppolyf_u_CDNS_406619531453_2/MINUS
+ comp018green_esd_rc_v5p0_0/ppolyf_u_CDNS_406619531453_3/MINUS comp018green_esd_rc_v5p0_0/ppolyf_u_CDNS_406619531453_4/PLUS
+ comp018green_esd_rc_v5p0_0/ppolyf_u_CDNS_406619531453_4/MINUS comp018green_esd_rc_v5p0_0/ppolyf_u_CDNS_406619531453_5/MINUS
+ M2_M1_CDNS_40661953145118_7/m1_n974_n38# comp018green_esd_rc_v5p0_0/ppolyf_u_CDNS_406619531453_1/PLUS
+ comp018green_esd_rc_v5p0_0/ppolyf_u_CDNS_406619531453_6/MINUS comp018green_esd_rc_v5p0_0/ppolyf_u_CDNS_406619531453_7/MINUS
+ comp018green_esd_rc_v5p0_0/ppolyf_u_CDNS_406619531453_8/MINUS comp018green_esd_rc_v5p0_0/ppolyf_u_CDNS_406619531453_9/MINUS
+ comp018green_esd_rc_v5p0_0/ppolyf_u_CDNS_406619531453_8/PLUS comp018green_esd_rc_v5p0_0/ppolyf_u_CDNS_406619531453_5/PLUS
+ comp018green_esd_rc_v5p0_0/ppolyf_u_CDNS_406619531453_2/PLUS comp018green_esd_rc_v5p0_0/ppolyf_u_CDNS_406619531453_10/PLUS
+ comp018green_esd_rc_v5p0_0/ppolyf_u_CDNS_406619531453_9/PLUS comp018green_esd_rc_v5p0_0/ppolyf_u_CDNS_406619531453_6/PLUS
+ VSUBS comp018green_esd_rc_v5p0
Xpmos_6p0_CDNS_406619531452_0 pmos_6p0_CDNS_406619531456_0/S pmos_6p0_CDNS_406619531452_0/D
+ pmos_6p0_CDNS_406619531452_0/a_732_n44# pmos_6p0_CDNS_406619531452_0/a_0_n44# pmos_6p0_CDNS_406619531456_0/S
+ pmos_6p0_CDNS_406619531452_0/a_244_n44# pmos_6p0_CDNS_406619531452_0/a_488_n44#
+ pmos_6p0_CDNS_406619531452
Xnmos_6p0_CDNS_406619531458_0 nmos_6p0_CDNS_406619531458_0/D nmos_6p0_CDNS_406619531458_0/a_732_n44#
+ nmos_6p0_CDNS_406619531458_0/a_976_n44# nmos_6p0_CDNS_406619531458_0/a_0_n44# nmos_6p0_CDNS_406619531458_1/S
+ nmos_6p0_CDNS_406619531458_0/a_1220_n44# nmos_6p0_CDNS_406619531458_0/a_244_n44#
+ nmos_6p0_CDNS_406619531458_0/a_488_n44# VSUBS nmos_6p0_CDNS_406619531458
Xnmos_clamp_20_50_4_DVDD_0 nmos_clamp_20_50_4_DVDD_0/nmos_6p0_CDNS_406619531457_2/a_732_n44#
+ nmos_clamp_20_50_4_DVDD_0/nmos_6p0_CDNS_406619531457_3/a_0_n44# nmos_clamp_20_50_4_DVDD_0/nmos_6p0_CDNS_406619531457_2/a_976_n44#
+ nmos_clamp_20_50_4_DVDD_0/M2_M1_CDNS_40661953145136_6/m1_n92_n2414# nmos_clamp_20_50_4_DVDD_0/nmos_6p0_CDNS_406619531457_0/a_4636_n44#
+ nmos_clamp_20_50_4_DVDD_0/nmos_6p0_CDNS_406619531457_0/a_3660_n44# nmos_clamp_20_50_4_DVDD_0/M2_M1_CDNS_40661953145136_2/m1_n92_n2414#
+ nmos_clamp_20_50_4_DVDD_0/nmos_6p0_CDNS_406619531457_2/D nmos_clamp_20_50_4_DVDD_0/nmos_6p0_CDNS_406619531457_1/a_3660_n44#
+ nmos_clamp_20_50_4_DVDD_0/nmos_6p0_CDNS_406619531457_1/a_4636_n44# nmos_clamp_20_50_4_DVDD_0/nmos_6p0_CDNS_406619531457_0/a_2440_n44#
+ nmos_clamp_20_50_4_DVDD_0/nmos_6p0_CDNS_406619531457_0/a_3416_n44# nmos_clamp_20_50_4_DVDD_0/nmos_6p0_CDNS_406619531457_3/a_732_n44#
+ nmos_clamp_20_50_4_DVDD_0/nmos_6p0_CDNS_406619531457_2/a_3660_n44# nmos_clamp_20_50_4_DVDD_0/nmos_6p0_CDNS_406619531457_2/a_4636_n44#
+ nmos_clamp_20_50_4_DVDD_0/nmos_6p0_CDNS_406619531457_0/a_0_n44# nmos_clamp_20_50_4_DVDD_0/nmos_6p0_CDNS_406619531457_0/a_2684_n44#
+ nmos_clamp_20_50_4_DVDD_0/nmos_6p0_CDNS_406619531457_1/a_2440_n44# nmos_clamp_20_50_4_DVDD_0/nmos_6p0_CDNS_406619531457_1/a_3416_n44#
+ nmos_clamp_20_50_4_DVDD_0/nmos_6p0_CDNS_406619531457_0/a_1220_n44# nmos_clamp_20_50_4_DVDD_0/nmos_6p0_CDNS_406619531457_3/a_976_n44#
+ nmos_clamp_20_50_4_DVDD_0/nmos_6p0_CDNS_406619531457_3/a_3660_n44# nmos_clamp_20_50_4_DVDD_0/nmos_6p0_CDNS_406619531457_3/a_4636_n44#
+ nmos_clamp_20_50_4_DVDD_0/nmos_6p0_CDNS_406619531457_1/a_2684_n44# nmos_clamp_20_50_4_DVDD_0/nmos_6p0_CDNS_406619531457_2/a_2440_n44#
+ nmos_clamp_20_50_4_DVDD_0/nmos_6p0_CDNS_406619531457_2/a_3416_n44# nmos_clamp_20_50_4_DVDD_0/nmos_6p0_CDNS_406619531457_0/a_1464_n44#
+ nmos_clamp_20_50_4_DVDD_0/nmos_6p0_CDNS_406619531457_1/a_1220_n44# nmos_clamp_20_50_4_DVDD_0/nmos_6p0_CDNS_406619531457_2/a_2684_n44#
+ nmos_clamp_20_50_4_DVDD_0/nmos_6p0_CDNS_406619531457_1/a_1464_n44# nmos_clamp_20_50_4_DVDD_0/nmos_6p0_CDNS_406619531457_3/a_2440_n44#
+ nmos_clamp_20_50_4_DVDD_0/nmos_6p0_CDNS_406619531457_3/a_3416_n44# nmos_clamp_20_50_4_DVDD_0/nmos_6p0_CDNS_406619531457_2/a_1220_n44#
+ nmos_clamp_20_50_4_DVDD_0/nmos_6p0_CDNS_406619531457_3/a_2684_n44# nmos_clamp_20_50_4_DVDD_0/nmos_6p0_CDNS_406619531457_2/a_1464_n44#
+ nmos_clamp_20_50_4_DVDD_0/nmos_6p0_CDNS_406619531457_3/a_1220_n44# nmos_clamp_20_50_4_DVDD_0/nmos_6p0_CDNS_406619531457_3/a_1464_n44#
+ nmos_clamp_20_50_4_DVDD_0/M2_M1_CDNS_40661953145136_7/m1_n92_n2414# nmos_clamp_20_50_4_DVDD_0/M2_M1_CDNS_40661953145136_0/m1_n92_n2414#
+ nmos_clamp_20_50_4_DVDD_0/nmos_6p0_CDNS_406619531457_0/a_244_n44# nmos_clamp_20_50_4_DVDD_0/nmos_6p0_CDNS_406619531457_0/a_488_n44#
+ nmos_clamp_20_50_4_DVDD_0/nmos_6p0_CDNS_406619531457_1/a_0_n44# nmos_clamp_20_50_4_DVDD_0/M2_M1_CDNS_40661953145136_5/m1_n92_n2414#
+ nmos_clamp_20_50_4_DVDD_0/M2_M1_CDNS_40661953145136_1/m1_n92_n2414# nmos_clamp_20_50_4_DVDD_0/nmos_6p0_CDNS_406619531457_1/a_244_n44#
+ nmos_clamp_20_50_4_DVDD_0/nmos_6p0_CDNS_406619531457_1/a_488_n44# nmos_clamp_20_50_4_DVDD_0/nmos_6p0_CDNS_406619531457_0/a_3904_n44#
+ nmos_clamp_20_50_4_DVDD_0/nmos_6p0_CDNS_406619531457_2/a_244_n44# nmos_clamp_20_50_4_DVDD_0/nmos_6p0_CDNS_406619531457_1/a_3904_n44#
+ nmos_clamp_20_50_4_DVDD_0/nmos_6p0_CDNS_406619531457_0/a_4392_n44# nmos_clamp_20_50_4_DVDD_0/nmos_6p0_CDNS_406619531457_2/a_488_n44#
+ nmos_clamp_20_50_4_DVDD_0/nmos_6p0_CDNS_406619531457_2/a_3904_n44# nmos_clamp_20_50_4_DVDD_0/nmos_6p0_CDNS_406619531457_0/a_1952_n44#
+ nmos_clamp_20_50_4_DVDD_0/nmos_6p0_CDNS_406619531457_0/a_2928_n44# nmos_clamp_20_50_4_DVDD_0/nmos_6p0_CDNS_406619531457_1/a_4392_n44#
+ nmos_clamp_20_50_4_DVDD_0/nmos_6p0_CDNS_406619531457_3/D nmos_clamp_20_50_4_DVDD_0/nmos_6p0_CDNS_406619531457_0/a_3172_n44#
+ nmos_clamp_20_50_4_DVDD_0/nmos_6p0_CDNS_406619531457_0/a_4148_n44# nmos_clamp_20_50_4_DVDD_0/nmos_6p0_CDNS_406619531457_3/a_3904_n44#
+ nmos_clamp_20_50_4_DVDD_0/nmos_6p0_CDNS_406619531457_1/a_2928_n44# nmos_clamp_20_50_4_DVDD_0/nmos_6p0_CDNS_406619531457_1/a_1952_n44#
+ nmos_clamp_20_50_4_DVDD_0/nmos_6p0_CDNS_406619531457_2/a_4392_n44# nmos_clamp_20_50_4_DVDD_0/nmos_6p0_CDNS_406619531457_0/a_1708_n44#
+ nmos_clamp_20_50_4_DVDD_0/nmos_6p0_CDNS_406619531457_1/a_4148_n44# nmos_clamp_20_50_4_DVDD_0/nmos_6p0_CDNS_406619531457_1/a_3172_n44#
+ nmos_clamp_20_50_4_DVDD_0/nmos_6p0_CDNS_406619531457_2/a_1952_n44# nmos_clamp_20_50_4_DVDD_0/nmos_6p0_CDNS_406619531457_2/a_2928_n44#
+ nmos_clamp_20_50_4_DVDD_0/nmos_6p0_CDNS_406619531457_3/a_244_n44# nmos_clamp_20_50_4_DVDD_0/nmos_6p0_CDNS_406619531457_3/a_4392_n44#
+ nmos_clamp_20_50_4_DVDD_0/nmos_6p0_CDNS_406619531457_0/a_2196_n44# nmos_clamp_20_50_4_DVDD_0/nmos_6p0_CDNS_406619531457_1/a_1708_n44#
+ nmos_clamp_20_50_4_DVDD_0/nmos_6p0_CDNS_406619531457_2/a_4148_n44# nmos_clamp_20_50_4_DVDD_0/nmos_6p0_CDNS_406619531457_2/a_3172_n44#
+ nmos_clamp_20_50_4_DVDD_0/M2_M1_CDNS_40661953145136_4/m1_n92_n2414# nmos_clamp_20_50_4_DVDD_0/nmos_6p0_CDNS_406619531457_3/a_488_n44#
+ nmos_clamp_20_50_4_DVDD_0/nmos_6p0_CDNS_406619531457_3/a_1952_n44# nmos_clamp_20_50_4_DVDD_0/nmos_6p0_CDNS_406619531457_3/a_2928_n44#
+ nmos_clamp_20_50_4_DVDD_0/nmos_6p0_CDNS_406619531457_2/a_1708_n44# nmos_clamp_20_50_4_DVDD_0/nmos_6p0_CDNS_406619531457_1/a_2196_n44#
+ nmos_clamp_20_50_4_DVDD_0/nmos_6p0_CDNS_406619531457_3/a_3172_n44# nmos_clamp_20_50_4_DVDD_0/nmos_6p0_CDNS_406619531457_3/a_4148_n44#
+ nmos_clamp_20_50_4_DVDD_0/nmos_6p0_CDNS_406619531457_3/a_1708_n44# nmos_clamp_20_50_4_DVDD_0/nmos_6p0_CDNS_406619531457_2/a_2196_n44#
+ nmos_clamp_20_50_4_DVDD_0/nmos_6p0_CDNS_406619531457_2/a_0_n44# nmos_clamp_20_50_4_DVDD_0/nmos_6p0_CDNS_406619531457_3/a_2196_n44#
+ nmos_clamp_20_50_4_DVDD_0/nmos_6p0_CDNS_406619531457_1/S nmos_clamp_20_50_4_DVDD_0/nmos_6p0_CDNS_406619531457_0/a_732_n44#
+ nmos_clamp_20_50_4_DVDD_0/nmos_6p0_CDNS_406619531457_0/a_976_n44# nmos_clamp_20_50_4_DVDD_0/M2_M1_CDNS_40661953145136_3/m1_n92_n2414#
+ nmos_clamp_20_50_4_DVDD_0/nmos_6p0_CDNS_406619531457_1/D nmos_clamp_20_50_4_DVDD_0/nmos_6p0_CDNS_406619531457_1/a_732_n44#
+ nmos_clamp_20_50_4_DVDD_0/nmos_6p0_CDNS_406619531457_1/a_976_n44# nmos_clamp_20_50_4_DVDD_0/nmos_6p0_CDNS_406619531457_0/S
+ nmos_clamp_20_50_4_DVDD_0/nmos_6p0_CDNS_406619531457_0/D nmos_clamp_20_50_4_DVDD_0/nmos_6p0_CDNS_406619531457_2/S
+ VSUBS nmos_clamp_20_50_4_DVDD_0/nmos_6p0_CDNS_406619531457_3/S nmos_clamp_20_50_4_DVDD_0/M2_M1_CDNS_40661953145139_3/m1_n308_n146#
+ nmos_clamp_20_50_4_DVDD
Xnmos_6p0_CDNS_406619531458_1 nmos_6p0_CDNS_406619531458_1/D nmos_6p0_CDNS_406619531458_1/a_732_n44#
+ nmos_6p0_CDNS_406619531458_1/a_976_n44# nmos_6p0_CDNS_406619531458_1/a_0_n44# nmos_6p0_CDNS_406619531458_1/S
+ nmos_6p0_CDNS_406619531458_1/a_1220_n44# nmos_6p0_CDNS_406619531458_1/a_244_n44#
+ nmos_6p0_CDNS_406619531458_1/a_488_n44# VSUBS nmos_6p0_CDNS_406619531458
.ends

.subckt GF_NI_DVDD_BASE comp018green_esd_clamp_v5p0_DVDD_0/nmos_clamp_20_50_4_DVDD_0/nmos_6p0_CDNS_406619531457_0/a_3904_n44#
+ comp018green_esd_clamp_v5p0_DVDD_0/nmos_6p0_CDNS_406619531458_0/D comp018green_esd_clamp_v5p0_DVDD_0/nmos_clamp_20_50_4_DVDD_0/nmos_6p0_CDNS_406619531457_1/S
+ comp018green_esd_clamp_v5p0_DVDD_0/comp018green_esd_rc_v5p0_0/ppolyf_u_CDNS_406619531453_1/MINUS
+ comp018green_esd_clamp_v5p0_DVDD_0/nmos_clamp_20_50_4_DVDD_0/nmos_6p0_CDNS_406619531457_1/a_3904_n44#
+ comp018green_esd_clamp_v5p0_DVDD_0/nmos_clamp_20_50_4_DVDD_0/nmos_6p0_CDNS_406619531457_2/a_0_n44#
+ comp018green_esd_clamp_v5p0_DVDD_0/pmos_6p0_CDNS_406619531452_0/a_732_n44# M3_M2_CDNS_4066195314592_21/m2_n968_n658#
+ comp018green_esd_clamp_v5p0_DVDD_0/nmos_clamp_20_50_4_DVDD_0/nmos_6p0_CDNS_406619531457_0/a_4392_n44#
+ M3_M2_CDNS_4066195314590_15/m2_n906_n658# comp018green_esd_clamp_v5p0_DVDD_0/nmos_clamp_20_50_4_DVDD_0/nmos_6p0_CDNS_406619531457_2/a_3904_n44#
+ comp018green_esd_clamp_v5p0_DVDD_0/comp018green_esd_rc_v5p0_0/ppolyf_u_CDNS_406619531453_2/MINUS
+ comp018green_esd_clamp_v5p0_DVDD_0/comp018green_esd_rc_v5p0_0/ppolyf_u_CDNS_406619531453_8/PLUS
+ comp018green_esd_clamp_v5p0_DVDD_0/nmos_clamp_20_50_4_DVDD_0/nmos_6p0_CDNS_406619531457_0/a_1952_n44#
+ comp018green_esd_clamp_v5p0_DVDD_0/nmos_clamp_20_50_4_DVDD_0/nmos_6p0_CDNS_406619531457_0/a_2928_n44#
+ comp018green_esd_clamp_v5p0_DVDD_0/nmos_clamp_20_50_4_DVDD_0/nmos_6p0_CDNS_406619531457_1/a_244_n44#
+ comp018green_esd_clamp_v5p0_DVDD_0/nmos_clamp_20_50_4_DVDD_0/nmos_6p0_CDNS_406619531457_1/a_4392_n44#
+ comp018green_esd_clamp_v5p0_DVDD_0/nmos_clamp_20_50_4_DVDD_0/nmos_6p0_CDNS_406619531457_0/a_3172_n44#
+ comp018green_esd_clamp_v5p0_DVDD_0/nmos_clamp_20_50_4_DVDD_0/nmos_6p0_CDNS_406619531457_0/a_4148_n44#
+ M3_M2_CDNS_4066195314594_5/m2_n100_n658# M3_M2_CDNS_4066195314587_3/m2_n38_n686#
+ comp018green_esd_clamp_v5p0_DVDD_0/nmos_clamp_20_50_4_DVDD_0/nmos_6p0_CDNS_406619531457_3/a_3904_n44#
+ comp018green_esd_clamp_v5p0_DVDD_0/nmos_clamp_20_50_4_DVDD_0/nmos_6p0_CDNS_406619531457_1/a_488_n44#
+ comp018green_esd_clamp_v5p0_DVDD_0/nmos_clamp_20_50_4_DVDD_0/nmos_6p0_CDNS_406619531457_1/a_2928_n44#
+ comp018green_esd_clamp_v5p0_DVDD_0/nmos_clamp_20_50_4_DVDD_0/nmos_6p0_CDNS_406619531457_1/a_1952_n44#
+ comp018green_esd_clamp_v5p0_DVDD_0/nmos_clamp_20_50_4_DVDD_0/nmos_6p0_CDNS_406619531457_2/a_4392_n44#
+ comp018green_esd_clamp_v5p0_DVDD_0/nmos_6p0_CDNS_406619531458_0/a_1220_n44# comp018green_esd_clamp_v5p0_DVDD_0/nmos_clamp_20_50_4_DVDD_0/nmos_6p0_CDNS_406619531457_0/a_1708_n44#
+ comp018green_esd_clamp_v5p0_DVDD_0/nmos_clamp_20_50_4_DVDD_0/nmos_6p0_CDNS_406619531457_1/a_4148_n44#
+ comp018green_esd_clamp_v5p0_DVDD_0/nmos_clamp_20_50_4_DVDD_0/nmos_6p0_CDNS_406619531457_1/a_3172_n44#
+ M3_M2_CDNS_4066195314589_1/m2_n38_n632# comp018green_esd_clamp_v5p0_DVDD_0/nmos_6p0_CDNS_406619531458_0/a_0_n44#
+ comp018green_esd_clamp_v5p0_DVDD_0/comp018green_esd_rc_v5p0_0/ppolyf_u_CDNS_406619531453_3/MINUS
+ comp018green_esd_clamp_v5p0_DVDD_0/nmos_clamp_20_50_4_DVDD_0/nmos_6p0_CDNS_406619531457_2/a_1952_n44#
+ comp018green_esd_clamp_v5p0_DVDD_0/nmos_clamp_20_50_4_DVDD_0/nmos_6p0_CDNS_406619531457_2/a_2928_n44#
+ comp018green_esd_clamp_v5p0_DVDD_0/nmos_clamp_20_50_4_DVDD_0/nmos_6p0_CDNS_406619531457_3/a_4392_n44#
+ comp018green_esd_clamp_v5p0_DVDD_0/nmos_6p0_CDNS_406619531458_1/a_1220_n44# comp018green_esd_clamp_v5p0_DVDD_0/comp018green_esd_rc_v5p0_0/ppolyf_u_CDNS_406619531453_10/MINUS
+ comp018green_esd_clamp_v5p0_DVDD_0/nmos_clamp_20_50_4_DVDD_0/nmos_6p0_CDNS_406619531457_0/a_2196_n44#
+ comp018green_esd_clamp_v5p0_DVDD_0/nmos_clamp_20_50_4_DVDD_0/nmos_6p0_CDNS_406619531457_1/a_1708_n44#
+ comp018green_esd_clamp_v5p0_DVDD_0/nmos_clamp_20_50_4_DVDD_0/nmos_6p0_CDNS_406619531457_2/a_4148_n44#
+ comp018green_esd_clamp_v5p0_DVDD_0/nmos_clamp_20_50_4_DVDD_0/nmos_6p0_CDNS_406619531457_2/a_3172_n44#
+ comp018green_esd_clamp_v5p0_DVDD_0/nmos_clamp_20_50_4_DVDD_0/nmos_6p0_CDNS_406619531457_3/a_1952_n44#
+ comp018green_esd_clamp_v5p0_DVDD_0/nmos_clamp_20_50_4_DVDD_0/nmos_6p0_CDNS_406619531457_3/a_2928_n44#
+ comp018green_esd_clamp_v5p0_DVDD_0/comp018green_esd_rc_v5p0_0/ppolyf_u_CDNS_406619531453_4/MINUS
+ comp018green_esd_clamp_v5p0_DVDD_0/nmos_clamp_20_50_4_DVDD_0/M2_M1_CDNS_40661953145136_3/m1_n92_n2414#
+ comp018green_esd_clamp_v5p0_DVDD_0/nmos_clamp_20_50_4_DVDD_0/nmos_6p0_CDNS_406619531457_2/a_1708_n44#
+ comp018green_esd_clamp_v5p0_DVDD_0/comp018green_esd_rc_v5p0_0/ppolyf_u_CDNS_406619531453_5/PLUS
+ M3_M2_CDNS_4066195314592_12/m2_n968_n658# comp018green_esd_clamp_v5p0_DVDD_0/nmos_clamp_20_50_4_DVDD_0/nmos_6p0_CDNS_406619531457_1/a_2196_n44#
+ comp018green_esd_clamp_v5p0_DVDD_0/nmos_clamp_20_50_4_DVDD_0/nmos_6p0_CDNS_406619531457_3/a_3172_n44#
+ comp018green_esd_clamp_v5p0_DVDD_0/nmos_clamp_20_50_4_DVDD_0/nmos_6p0_CDNS_406619531457_3/a_4148_n44#
+ M3_M2_CDNS_4066195314593_18/m2_n968_n1464# comp018green_esd_clamp_v5p0_DVDD_0/pmos_6p0_CDNS_406619531455_0/a_0_n44#
+ comp018green_esd_clamp_v5p0_DVDD_0/M1_POLY2_CDNS_40661953145109_0/a_n653_n42# comp018green_esd_clamp_v5p0_DVDD_0/comp018green_esd_rc_v5p0_0/ppolyf_u_CDNS_406619531453_11/MINUS
+ comp018green_esd_clamp_v5p0_DVDD_0/nmos_clamp_20_50_4_DVDD_0/nmos_6p0_CDNS_406619531457_2/a_244_n44#
+ comp018green_esd_clamp_v5p0_DVDD_0/nmos_clamp_20_50_4_DVDD_0/nmos_6p0_CDNS_406619531457_3/a_1708_n44#
+ comp018green_esd_clamp_v5p0_DVDD_0/nmos_clamp_20_50_4_DVDD_0/nmos_6p0_CDNS_406619531457_2/a_2196_n44#
+ comp018green_esd_clamp_v5p0_DVDD_0/comp018green_esd_rc_v5p0_0/ppolyf_u_CDNS_406619531453_5/MINUS
+ comp018green_esd_clamp_v5p0_DVDD_0/nmos_clamp_20_50_4_DVDD_0/nmos_6p0_CDNS_406619531457_2/a_488_n44#
+ M3_M2_CDNS_4066195314594_8/m2_n100_n658# comp018green_esd_clamp_v5p0_DVDD_0/M1_POLY2_CDNS_40661953145109_1/a_n653_n42#
+ comp018green_esd_clamp_v5p0_DVDD_0/nmos_6p0_CDNS_406619531459_0/a_0_n44# M3_M2_CDNS_4066195314592_9/m2_n968_n658#
+ comp018green_esd_clamp_v5p0_DVDD_0/nmos_clamp_20_50_4_DVDD_0/nmos_6p0_CDNS_406619531457_3/a_2196_n44#
+ comp018green_esd_clamp_v5p0_DVDD_0/nmos_6p0_CDNS_406619531458_0/a_732_n44# comp018green_esd_clamp_v5p0_DVDD_0/comp018green_esd_rc_v5p0_0/ppolyf_u_CDNS_406619531453_6/MINUS
+ comp018green_esd_clamp_v5p0_DVDD_0/comp018green_esd_rc_v5p0_0/ppolyf_u_CDNS_406619531453_2/PLUS
+ comp018green_esd_clamp_v5p0_DVDD_0/nmos_6p0_CDNS_406619531458_0/a_976_n44# comp018green_esd_clamp_v5p0_DVDD_0/comp018green_esd_rc_v5p0_0/ppolyf_u_CDNS_406619531453_7/MINUS
+ comp018green_esd_clamp_v5p0_DVDD_0/nmos_clamp_20_50_4_DVDD_0/nmos_6p0_CDNS_406619531457_3/a_244_n44#
+ comp018green_esd_clamp_v5p0_DVDD_0/pmos_6p0_CDNS_406619531456_0/a_0_n44# M3_M2_CDNS_4066195314592_15/m2_n968_n658#
+ M3_M2_CDNS_4066195314592_27/m2_n968_n658# comp018green_esd_clamp_v5p0_DVDD_0/nmos_clamp_20_50_4_DVDD_0/nmos_6p0_CDNS_406619531457_3/a_488_n44#
+ M3_M2_CDNS_4066195314587_2/m2_n38_n686# M3_M2_CDNS_4066195314590_5/m2_n906_n658#
+ comp018green_esd_clamp_v5p0_DVDD_0/comp018green_esd_rc_v5p0_0/ppolyf_u_CDNS_406619531453_8/MINUS
+ M3_M2_CDNS_4066195314594_18/m2_n100_n658# comp018green_esd_clamp_v5p0_DVDD_0/pmos_6p0_CDNS_406619531455_0/a_3904_n44#
+ comp018green_esd_clamp_v5p0_DVDD_0/nmos_6p0_CDNS_406619531458_1/a_732_n44# M3_M2_CDNS_4066195314589_0/m2_n38_n632#
+ comp018green_esd_clamp_v5p0_DVDD_0/pmos_6p0_CDNS_406619531455_0/a_5124_n44# comp018green_esd_clamp_v5p0_DVDD_0/nmos_6p0_CDNS_406619531458_1/a_976_n44#
+ comp018green_esd_clamp_v5p0_DVDD_0/comp018green_esd_rc_v5p0_0/ppolyf_u_CDNS_406619531453_9/MINUS
+ comp018green_esd_clamp_v5p0_DVDD_0/nmos_6p0_CDNS_406619531459_0/D comp018green_esd_clamp_v5p0_DVDD_0/nmos_clamp_20_50_4_DVDD_0/M2_M1_CDNS_40661953145136_6/m1_n92_n2414#
+ comp018green_esd_clamp_v5p0_DVDD_0/pmos_6p0_CDNS_406619531455_0/a_5368_n44# comp018green_esd_clamp_v5p0_DVDD_0/pmos_6p0_CDNS_406619531455_0/a_4392_n44#
+ comp018green_esd_clamp_v5p0_DVDD_0/M1_POLY2_CDNS_40661953145110_0/a_n2862_n42# M3_M2_CDNS_4066195314592_4/m2_n968_n658#
+ comp018green_esd_clamp_v5p0_DVDD_0/nmos_clamp_20_50_4_DVDD_0/M2_M1_CDNS_40661953145136_2/m1_n92_n2414#
+ comp018green_esd_clamp_v5p0_DVDD_0/nmos_clamp_20_50_4_DVDD_0/nmos_6p0_CDNS_406619531457_3/a_0_n44#
+ comp018green_esd_clamp_v5p0_DVDD_0/pmos_6p0_CDNS_406619531455_0/a_1952_n44# comp018green_esd_clamp_v5p0_DVDD_0/pmos_6p0_CDNS_406619531455_0/a_2928_n44#
+ M3_M2_CDNS_4066195314590_3/m2_n906_n658# comp018green_esd_clamp_v5p0_DVDD_0/pmos_6p0_CDNS_406619531455_0/a_4148_n44#
+ comp018green_esd_clamp_v5p0_DVDD_0/pmos_6p0_CDNS_406619531455_0/a_3172_n44# M3_M2_CDNS_4066195314596_4/m2_n224_n658#
+ comp018green_esd_clamp_v5p0_DVDD_0/pmos_6p0_CDNS_406619531455_0/a_1708_n44# comp018green_esd_clamp_v5p0_DVDD_0/comp018green_esd_rc_v5p0_0/ppolyf_u_CDNS_406619531453_9/PLUS
+ comp018green_esd_clamp_v5p0_DVDD_0/nmos_6p0_CDNS_406619531458_1/a_0_n44# comp018green_esd_clamp_v5p0_DVDD_0/pmos_6p0_CDNS_406619531455_0/a_2196_n44#
+ M3_M2_CDNS_4066195314592_22/m2_n968_n658# M3_M2_CDNS_4066195314593_19/m2_n968_n1464#
+ M3_M2_CDNS_4066195314590_16/m2_n906_n658# comp018green_esd_clamp_v5p0_DVDD_0/pmos_6p0_CDNS_406619531455_0/a_732_n44#
+ comp018green_esd_clamp_v5p0_DVDD_0/nmos_clamp_20_50_4_DVDD_0/nmos_6p0_CDNS_406619531457_0/a_732_n44#
+ comp018green_esd_clamp_v5p0_DVDD_0/nmos_clamp_20_50_4_DVDD_0/nmos_6p0_CDNS_406619531457_0/a_0_n44#
+ comp018green_esd_clamp_v5p0_DVDD_0/M2_M1_CDNS_40661953145103_0/m1_n92_n92# comp018green_esd_clamp_v5p0_DVDD_0/pmos_6p0_CDNS_406619531455_0/a_976_n44#
+ comp018green_esd_clamp_v5p0_DVDD_0/comp018green_esd_rc_v5p0_0/ppolyf_u_CDNS_406619531453_6/PLUS
+ M3_M2_CDNS_4066195314592_7/m2_n968_n658# comp018green_esd_clamp_v5p0_DVDD_0/nmos_clamp_20_50_4_DVDD_0/nmos_6p0_CDNS_406619531457_0/a_976_n44#
+ M3_M2_CDNS_4066195314594_13/m2_n100_n658# M3_M2_CDNS_4066195314590_6/m2_n906_n658#
+ comp018green_esd_clamp_v5p0_DVDD_0/M2_M1_CDNS_40661953145103_1/m1_n92_n92# comp018green_esd_clamp_v5p0_DVDD_0/M2_M1_CDNS_40661953145117_0/m1_n90_n38#
+ M3_M2_CDNS_4066195314587_1/m2_n38_n686# comp018green_esd_clamp_v5p0_DVDD_0/M2_M1_CDNS_40661953145117_1/m1_n90_n38#
+ M3_M2_CDNS_4066195314592_13/m2_n968_n658# comp018green_esd_clamp_v5p0_DVDD_0/M2_M1_CDNS_40661953145117_2/m1_n90_n38#
+ M3_M2_CDNS_4066195314584_8/m2_n906_n1464# comp018green_esd_clamp_v5p0_DVDD_0/nmos_clamp_20_50_4_DVDD_0/nmos_6p0_CDNS_406619531457_1/a_732_n44#
+ comp018green_esd_clamp_v5p0_DVDD_0/comp018green_esd_rc_v5p0_0/ppolyf_u_CDNS_406619531453_3/PLUS
+ comp018green_esd_clamp_v5p0_DVDD_0/nmos_clamp_20_50_4_DVDD_0/nmos_6p0_CDNS_406619531457_0/a_4636_n44#
+ comp018green_esd_clamp_v5p0_DVDD_0/nmos_clamp_20_50_4_DVDD_0/nmos_6p0_CDNS_406619531457_0/a_3660_n44#
+ comp018green_esd_clamp_v5p0_DVDD_0/nmos_clamp_20_50_4_DVDD_0/M2_M1_CDNS_40661953145136_7/m1_n92_n2414#
+ comp018green_esd_clamp_v5p0_DVDD_0/nmos_clamp_20_50_4_DVDD_0/nmos_6p0_CDNS_406619531457_1/a_976_n44#
+ comp018green_esd_clamp_v5p0_DVDD_0/nmos_clamp_20_50_4_DVDD_0/nmos_6p0_CDNS_406619531457_3/D
+ M3_M2_CDNS_4066195314592_25/m2_n968_n658# comp018green_esd_clamp_v5p0_DVDD_0/nmos_clamp_20_50_4_DVDD_0/M2_M1_CDNS_40661953145136_0/m1_n92_n2414#
+ comp018green_esd_clamp_v5p0_DVDD_0/nmos_clamp_20_50_4_DVDD_0/nmos_6p0_CDNS_406619531457_1/a_3660_n44#
+ comp018green_esd_clamp_v5p0_DVDD_0/nmos_clamp_20_50_4_DVDD_0/nmos_6p0_CDNS_406619531457_1/a_4636_n44#
+ comp018green_esd_clamp_v5p0_DVDD_0/nmos_6p0_CDNS_406619531458_1/D comp018green_esd_clamp_v5p0_DVDD_0/nmos_clamp_20_50_4_DVDD_0/nmos_6p0_CDNS_406619531457_0/a_2440_n44#
+ comp018green_esd_clamp_v5p0_DVDD_0/nmos_clamp_20_50_4_DVDD_0/nmos_6p0_CDNS_406619531457_0/a_3416_n44#
+ M3_M2_CDNS_4066195314590_9/m2_n906_n658# comp018green_esd_clamp_v5p0_DVDD_0/nmos_clamp_20_50_4_DVDD_0/nmos_6p0_CDNS_406619531457_2/a_3660_n44#
+ comp018green_esd_clamp_v5p0_DVDD_0/nmos_clamp_20_50_4_DVDD_0/nmos_6p0_CDNS_406619531457_2/a_4636_n44#
+ comp018green_esd_clamp_v5p0_DVDD_0/pmos_6p0_CDNS_406619531452_0/a_244_n44# M3_M2_CDNS_4066195314590_11/m2_n906_n658#
+ comp018green_esd_clamp_v5p0_DVDD_0/nmos_clamp_20_50_4_DVDD_0/nmos_6p0_CDNS_406619531457_0/a_2684_n44#
+ comp018green_esd_clamp_v5p0_DVDD_0/nmos_clamp_20_50_4_DVDD_0/nmos_6p0_CDNS_406619531457_1/a_2440_n44#
+ comp018green_esd_clamp_v5p0_DVDD_0/nmos_clamp_20_50_4_DVDD_0/nmos_6p0_CDNS_406619531457_1/a_3416_n44#
+ comp018green_esd_clamp_v5p0_DVDD_0/M2_M1_CDNS_40661953145117_5/m1_n90_n38# comp018green_esd_clamp_v5p0_DVDD_0/nmos_clamp_20_50_4_DVDD_0/nmos_6p0_CDNS_406619531457_0/a_1220_n44#
+ M3_M2_CDNS_4066195314594_1/m2_n100_n658# comp018green_esd_clamp_v5p0_DVDD_0/nmos_clamp_20_50_4_DVDD_0/nmos_6p0_CDNS_406619531457_3/a_3660_n44#
+ comp018green_esd_clamp_v5p0_DVDD_0/nmos_clamp_20_50_4_DVDD_0/nmos_6p0_CDNS_406619531457_3/a_4636_n44#
+ comp018green_esd_clamp_v5p0_DVDD_0/comp018green_esd_rc_v5p0_0/ppolyf_u_CDNS_406619531453_0/PLUS
+ comp018green_esd_clamp_v5p0_DVDD_0/pmos_6p0_CDNS_406619531452_0/a_488_n44# comp018green_esd_clamp_v5p0_DVDD_0/nmos_clamp_20_50_4_DVDD_0/nmos_6p0_CDNS_406619531457_1/a_2684_n44#
+ comp018green_esd_clamp_v5p0_DVDD_0/nmos_clamp_20_50_4_DVDD_0/nmos_6p0_CDNS_406619531457_2/a_2440_n44#
+ comp018green_esd_clamp_v5p0_DVDD_0/nmos_clamp_20_50_4_DVDD_0/nmos_6p0_CDNS_406619531457_2/a_3416_n44#
+ comp018green_esd_clamp_v5p0_DVDD_0/nmos_6p0_CDNS_406619531458_1/S M3_M2_CDNS_4066195314592_6/m2_n968_n658#
+ comp018green_esd_clamp_v5p0_DVDD_0/nmos_clamp_20_50_4_DVDD_0/nmos_6p0_CDNS_406619531457_0/a_1464_n44#
+ comp018green_esd_clamp_v5p0_DVDD_0/nmos_clamp_20_50_4_DVDD_0/nmos_6p0_CDNS_406619531457_1/a_1220_n44#
+ comp018green_esd_clamp_v5p0_DVDD_0/nmos_clamp_20_50_4_DVDD_0/nmos_6p0_CDNS_406619531457_2/a_732_n44#
+ M3_M2_CDNS_4066195314593_16/m2_n968_n1464# comp018green_esd_clamp_v5p0_DVDD_0/nmos_clamp_20_50_4_DVDD_0/nmos_6p0_CDNS_406619531457_2/a_2684_n44#
+ M3_M2_CDNS_4066195314596_2/m2_n224_n658# comp018green_esd_clamp_v5p0_DVDD_0/pmos_6p0_CDNS_406619531456_0/S
+ M3_M2_CDNS_4066195314592_28/m2_n968_n658# comp018green_esd_clamp_v5p0_DVDD_0/nmos_clamp_20_50_4_DVDD_0/nmos_6p0_CDNS_406619531457_1/a_1464_n44#
+ comp018green_esd_clamp_v5p0_DVDD_0/nmos_clamp_20_50_4_DVDD_0/nmos_6p0_CDNS_406619531457_3/a_2440_n44#
+ comp018green_esd_clamp_v5p0_DVDD_0/nmos_clamp_20_50_4_DVDD_0/nmos_6p0_CDNS_406619531457_3/a_3416_n44#
+ comp018green_esd_clamp_v5p0_DVDD_0/nmos_clamp_20_50_4_DVDD_0/nmos_6p0_CDNS_406619531457_2/a_1220_n44#
+ comp018green_esd_clamp_v5p0_DVDD_0/nmos_clamp_20_50_4_DVDD_0/nmos_6p0_CDNS_406619531457_2/a_976_n44#
+ comp018green_esd_clamp_v5p0_DVDD_0/nmos_clamp_20_50_4_DVDD_0/nmos_6p0_CDNS_406619531457_3/a_2684_n44#
+ comp018green_esd_clamp_v5p0_DVDD_0/nmos_clamp_20_50_4_DVDD_0/nmos_6p0_CDNS_406619531457_2/a_1464_n44#
+ comp018green_esd_clamp_v5p0_DVDD_0/nmos_clamp_20_50_4_DVDD_0/nmos_6p0_CDNS_406619531457_3/a_1220_n44#
+ comp018green_esd_clamp_v5p0_DVDD_0/M1_POLY2_CDNS_40661953145105_0/a_n371_n42# comp018green_esd_clamp_v5p0_DVDD_0/comp018green_esd_rc_v5p0_0/ppolyf_u_CDNS_406619531453_10/PLUS
+ M3_M2_CDNS_4066195314594_19/m2_n100_n658# comp018green_esd_clamp_v5p0_DVDD_0/nmos_clamp_20_50_4_DVDD_0/nmos_6p0_CDNS_406619531457_3/a_1464_n44#
+ comp018green_esd_clamp_v5p0_DVDD_0/pmos_6p0_CDNS_406619531455_0/D M3_M2_CDNS_4066195314587_0/m2_n38_n686#
+ M3_M2_CDNS_4066195314590_14/m2_n906_n658# M3_M2_CDNS_4066195314594_4/m2_n100_n658#
+ comp018green_esd_clamp_v5p0_DVDD_0/nmos_clamp_20_50_4_DVDD_0/nmos_6p0_CDNS_406619531457_3/a_732_n44#
+ M3_M2_CDNS_4066195314594_11/m2_n100_n658# comp018green_esd_clamp_v5p0_DVDD_0/nmos_clamp_20_50_4_DVDD_0/nmos_6p0_CDNS_406619531457_0/S
+ M3_M2_CDNS_4066195314592_5/m2_n968_n658# np_6p0_CDNS_406619531451_0/MINUS comp018green_esd_clamp_v5p0_DVDD_0/nmos_clamp_20_50_4_DVDD_0/nmos_6p0_CDNS_406619531457_3/a_976_n44#
+ comp018green_esd_clamp_v5p0_DVDD_0/nmos_clamp_20_50_4_DVDD_0/M2_M1_CDNS_40661953145136_5/m1_n92_n2414#
+ comp018green_esd_clamp_v5p0_DVDD_0/nmos_clamp_20_50_4_DVDD_0/nmos_6p0_CDNS_406619531457_1/a_0_n44#
+ comp018green_esd_clamp_v5p0_DVDD_0/nmos_6p0_CDNS_406619531458_0/a_244_n44# comp018green_esd_clamp_v5p0_DVDD_0/pmos_6p0_CDNS_406619531452_0/D
+ comp018green_esd_clamp_v5p0_DVDD_0/nmos_clamp_20_50_4_DVDD_0/M2_M1_CDNS_40661953145136_1/m1_n92_n2414#
+ comp018green_esd_clamp_v5p0_DVDD_0/comp018green_esd_rc_v5p0_0/ppolyf_u_CDNS_406619531453_7/PLUS
+ comp018green_esd_clamp_v5p0_DVDD_0/M2_M1_CDNS_40661953145112_0/m1_n246_n38# comp018green_esd_clamp_v5p0_DVDD_0/pmos_6p0_CDNS_406619531455_0/a_5612_n44#
+ comp018green_esd_clamp_v5p0_DVDD_0/nmos_6p0_CDNS_406619531458_0/a_488_n44# comp018green_esd_clamp_v5p0_DVDD_0/pmos_6p0_CDNS_406619531456_0/a_244_n44#
+ comp018green_esd_clamp_v5p0_DVDD_0/M1_POLY2_CDNS_40661953145106_0/a_n89_n42# M3_M2_CDNS_4066195314592_23/m2_n968_n658#
+ np_6p0_CDNS_406619531451_2/MINUS comp018green_esd_clamp_v5p0_DVDD_0/pmos_6p0_CDNS_406619531455_0/a_4880_n44#
+ M3_M2_CDNS_4066195314584_9/m2_n906_n1464# M3_M2_CDNS_4066195314592_31/m2_n968_n658#
+ comp018green_esd_clamp_v5p0_DVDD_0/pmos_6p0_CDNS_406619531456_0/a_488_n44# M3_M2_CDNS_4066195314590_17/m2_n906_n658#
+ comp018green_esd_clamp_v5p0_DVDD_0/M1_POLY2_CDNS_40661953145108_0/a_n277_n42# comp018green_esd_clamp_v5p0_DVDD_0/pmos_6p0_CDNS_406619531455_0/a_4636_n44#
+ comp018green_esd_clamp_v5p0_DVDD_0/pmos_6p0_CDNS_406619531455_0/a_3660_n44# M3_M2_CDNS_4066195314590_12/m2_n906_n658#
+ M3_M2_CDNS_4066195314594_14/m2_n100_n658# np_6p0_CDNS_406619531451_3/MINUS comp018green_esd_clamp_v5p0_DVDD_0/comp018green_esd_rc_v5p0_0/ppolyf_u_CDNS_406619531453_4/PLUS
+ M3_M2_CDNS_4066195314590_7/m2_n906_n658# comp018green_esd_clamp_v5p0_DVDD_0/pmos_6p0_CDNS_406619531455_0/a_3416_n44#
+ comp018green_esd_clamp_v5p0_DVDD_0/pmos_6p0_CDNS_406619531455_0/a_2440_n44# comp018green_esd_clamp_v5p0_DVDD_0/nmos_6p0_CDNS_406619531458_1/a_244_n44#
+ comp018green_esd_clamp_v5p0_DVDD_0/pmos_6p0_CDNS_406619531455_0/a_2684_n44# comp018green_esd_clamp_v5p0_DVDD_0/nmos_6p0_CDNS_406619531458_1/a_488_n44#
+ comp018green_esd_clamp_v5p0_DVDD_0/pmos_6p0_CDNS_406619531455_0/a_1220_n44# M3_M2_CDNS_4066195314592_19/m2_n968_n658#
+ comp018green_esd_clamp_v5p0_DVDD_0/pmos_6p0_CDNS_406619531452_0/a_0_n44# M3_M2_CDNS_4066195314593_17/m2_n968_n1464#
+ M3_M2_CDNS_4066195314592_26/m2_n968_n658# M3_M2_CDNS_4066195314592_14/m2_n968_n658#
+ comp018green_esd_clamp_v5p0_DVDD_0/pmos_6p0_CDNS_406619531455_0/a_1464_n44# comp018green_esd_clamp_v5p0_DVDD_0/comp018green_esd_rc_v5p0_0/ppolyf_u_CDNS_406619531453_1/PLUS
+ comp018green_esd_clamp_v5p0_DVDD_0/nmos_6p0_CDNS_406619531459_0/S comp018green_esd_clamp_v5p0_DVDD_0/nmos_clamp_20_50_4_DVDD_0/M2_M1_CDNS_40661953145136_4/m1_n92_n2414#
+ M3_M2_CDNS_4066195314590_8/m2_n906_n658# M3_M2_CDNS_4066195314594_2/m2_n100_n658#
+ comp018green_esd_clamp_v5p0_DVDD_0/pmos_6p0_CDNS_406619531455_0/a_244_n44# comp018green_esd_clamp_v5p0_DVDD_0/nmos_clamp_20_50_4_DVDD_0/nmos_6p0_CDNS_406619531457_0/a_244_n44#
+ comp018green_esd_clamp_v5p0_DVDD_0/pmos_6p0_CDNS_406619531456_0/D comp018green_esd_clamp_v5p0_DVDD_0/comp018green_esd_rc_v5p0_0/ppolyf_u_CDNS_406619531453_11/PLUS
+ M3_M2_CDNS_4066195314590_2/m2_n906_n658# comp018green_esd_clamp_v5p0_DVDD_0/nmos_clamp_20_50_4_DVDD_0/nmos_6p0_CDNS_406619531457_3/S
+ comp018green_esd_clamp_v5p0_DVDD_0/pmos_6p0_CDNS_406619531455_0/a_488_n44# comp018green_esd_clamp_v5p0_DVDD_0/comp018green_esd_rc_v5p0_0/ppolyf_u_CDNS_406619531453_0/MINUS
+ M3_M2_CDNS_4066195314592_17/m2_n968_n658# M3_M2_CDNS_4066195314592_29/m2_n968_n658#
+ comp018green_esd_clamp_v5p0_DVDD_0/nmos_clamp_20_50_4_DVDD_0/nmos_6p0_CDNS_406619531457_0/a_488_n44#
+ VSUBS comp018green_esd_clamp_v5p0_DVDD_0/nmos_clamp_20_50_4_DVDD_0/nmos_6p0_CDNS_406619531457_2/D
Xcomp018green_esd_clamp_v5p0_DVDD_0 comp018green_esd_clamp_v5p0_DVDD_0/M2_M1_CDNS_40661953145117_5/m1_n90_n38#
+ comp018green_esd_clamp_v5p0_DVDD_0/pmos_6p0_CDNS_406619531452_0/a_244_n44# comp018green_esd_clamp_v5p0_DVDD_0/nmos_clamp_20_50_4_DVDD_0/M2_M1_CDNS_40661953145136_4/m1_n92_n2414#
+ comp018green_esd_clamp_v5p0_DVDD_0/pmos_6p0_CDNS_406619531452_0/D comp018green_esd_clamp_v5p0_DVDD_0/nmos_clamp_20_50_4_DVDD_0/nmos_6p0_CDNS_406619531457_3/a_732_n44#
+ comp018green_esd_clamp_v5p0_DVDD_0/pmos_6p0_CDNS_406619531452_0/a_488_n44# comp018green_esd_clamp_v5p0_DVDD_0/nmos_clamp_20_50_4_DVDD_0/nmos_6p0_CDNS_406619531457_3/a_976_n44#
+ comp018green_esd_clamp_v5p0_DVDD_0/comp018green_esd_rc_v5p0_0/ppolyf_u_CDNS_406619531453_8/PLUS
+ comp018green_esd_clamp_v5p0_DVDD_0/M1_POLY2_CDNS_40661953145106_0/a_n89_n42# comp018green_esd_clamp_v5p0_DVDD_0/nmos_clamp_20_50_4_DVDD_0/nmos_6p0_CDNS_406619531457_2/D
+ comp018green_esd_clamp_v5p0_DVDD_0/comp018green_esd_rc_v5p0_0/ppolyf_u_CDNS_406619531453_10/PLUS
+ comp018green_esd_clamp_v5p0_DVDD_0/comp018green_esd_rc_v5p0_0/ppolyf_u_CDNS_406619531453_5/PLUS
+ comp018green_esd_clamp_v5p0_DVDD_0/M2_M1_CDNS_40661953145112_0/m1_n246_n38# comp018green_esd_clamp_v5p0_DVDD_0/pmos_6p0_CDNS_406619531455_0/a_5612_n44#
+ comp018green_esd_clamp_v5p0_DVDD_0/nmos_clamp_20_50_4_DVDD_0/nmos_6p0_CDNS_406619531457_0/a_3904_n44#
+ comp018green_esd_clamp_v5p0_DVDD_0/nmos_6p0_CDNS_406619531459_0/S comp018green_esd_clamp_v5p0_DVDD_0/nmos_6p0_CDNS_406619531458_0/a_244_n44#
+ M3_M2_CDNS_4066195314592_31/m2_n968_n658# comp018green_esd_clamp_v5p0_DVDD_0/pmos_6p0_CDNS_406619531455_0/a_4880_n44#
+ comp018green_esd_clamp_v5p0_DVDD_0/pmos_6p0_CDNS_406619531456_0/a_244_n44# comp018green_esd_clamp_v5p0_DVDD_0/nmos_clamp_20_50_4_DVDD_0/nmos_6p0_CDNS_406619531457_1/a_3904_n44#
+ comp018green_esd_clamp_v5p0_DVDD_0/nmos_6p0_CDNS_406619531458_0/a_488_n44# comp018green_esd_clamp_v5p0_DVDD_0/nmos_clamp_20_50_4_DVDD_0/nmos_6p0_CDNS_406619531457_0/a_4392_n44#
+ comp018green_esd_clamp_v5p0_DVDD_0/comp018green_esd_rc_v5p0_0/ppolyf_u_CDNS_406619531453_2/PLUS
+ comp018green_esd_clamp_v5p0_DVDD_0/nmos_clamp_20_50_4_DVDD_0/nmos_6p0_CDNS_406619531457_2/a_0_n44#
+ comp018green_esd_clamp_v5p0_DVDD_0/nmos_6p0_CDNS_406619531458_0/a_0_n44# comp018green_esd_clamp_v5p0_DVDD_0/pmos_6p0_CDNS_406619531456_0/a_488_n44#
+ comp018green_esd_clamp_v5p0_DVDD_0/nmos_clamp_20_50_4_DVDD_0/nmos_6p0_CDNS_406619531457_2/a_3904_n44#
+ comp018green_esd_clamp_v5p0_DVDD_0/pmos_6p0_CDNS_406619531455_0/a_3660_n44# comp018green_esd_clamp_v5p0_DVDD_0/nmos_clamp_20_50_4_DVDD_0/nmos_6p0_CDNS_406619531457_0/a_2928_n44#
+ comp018green_esd_clamp_v5p0_DVDD_0/nmos_clamp_20_50_4_DVDD_0/nmos_6p0_CDNS_406619531457_0/a_1952_n44#
+ comp018green_esd_clamp_v5p0_DVDD_0/nmos_clamp_20_50_4_DVDD_0/M2_M1_CDNS_40661953145136_3/m1_n92_n2414#
+ comp018green_esd_clamp_v5p0_DVDD_0/pmos_6p0_CDNS_406619531455_0/a_4636_n44# comp018green_esd_clamp_v5p0_DVDD_0/nmos_clamp_20_50_4_DVDD_0/nmos_6p0_CDNS_406619531457_1/a_4392_n44#
+ comp018green_esd_clamp_v5p0_DVDD_0/nmos_clamp_20_50_4_DVDD_0/nmos_6p0_CDNS_406619531457_0/a_3172_n44#
+ comp018green_esd_clamp_v5p0_DVDD_0/nmos_clamp_20_50_4_DVDD_0/nmos_6p0_CDNS_406619531457_0/a_4148_n44#
+ comp018green_esd_clamp_v5p0_DVDD_0/nmos_clamp_20_50_4_DVDD_0/nmos_6p0_CDNS_406619531457_3/a_3904_n44#
+ comp018green_esd_clamp_v5p0_DVDD_0/nmos_clamp_20_50_4_DVDD_0/nmos_6p0_CDNS_406619531457_1/a_1952_n44#
+ comp018green_esd_clamp_v5p0_DVDD_0/nmos_clamp_20_50_4_DVDD_0/nmos_6p0_CDNS_406619531457_1/a_2928_n44#
+ comp018green_esd_clamp_v5p0_DVDD_0/nmos_clamp_20_50_4_DVDD_0/nmos_6p0_CDNS_406619531457_2/a_4392_n44#
+ comp018green_esd_clamp_v5p0_DVDD_0/pmos_6p0_CDNS_406619531456_0/D comp018green_esd_clamp_v5p0_DVDD_0/pmos_6p0_CDNS_406619531455_0/a_3416_n44#
+ comp018green_esd_clamp_v5p0_DVDD_0/pmos_6p0_CDNS_406619531455_0/a_2440_n44# comp018green_esd_clamp_v5p0_DVDD_0/nmos_clamp_20_50_4_DVDD_0/nmos_6p0_CDNS_406619531457_0/a_1708_n44#
+ comp018green_esd_clamp_v5p0_DVDD_0/nmos_clamp_20_50_4_DVDD_0/nmos_6p0_CDNS_406619531457_1/a_3172_n44#
+ comp018green_esd_clamp_v5p0_DVDD_0/nmos_clamp_20_50_4_DVDD_0/nmos_6p0_CDNS_406619531457_1/a_4148_n44#
+ comp018green_esd_clamp_v5p0_DVDD_0/nmos_clamp_20_50_4_DVDD_0/nmos_6p0_CDNS_406619531457_2/a_2928_n44#
+ comp018green_esd_clamp_v5p0_DVDD_0/nmos_clamp_20_50_4_DVDD_0/nmos_6p0_CDNS_406619531457_2/a_1952_n44#
+ comp018green_esd_clamp_v5p0_DVDD_0/M1_POLY2_CDNS_40661953145110_0/a_n2862_n42# comp018green_esd_clamp_v5p0_DVDD_0/nmos_6p0_CDNS_406619531458_1/a_244_n44#
+ comp018green_esd_clamp_v5p0_DVDD_0/nmos_clamp_20_50_4_DVDD_0/nmos_6p0_CDNS_406619531457_3/a_4392_n44#
+ comp018green_esd_clamp_v5p0_DVDD_0/pmos_6p0_CDNS_406619531455_0/a_2684_n44# comp018green_esd_clamp_v5p0_DVDD_0/pmos_6p0_CDNS_406619531455_0/a_0_n44#
+ comp018green_esd_clamp_v5p0_DVDD_0/nmos_clamp_20_50_4_DVDD_0/nmos_6p0_CDNS_406619531457_1/a_1708_n44#
+ comp018green_esd_clamp_v5p0_DVDD_0/nmos_clamp_20_50_4_DVDD_0/nmos_6p0_CDNS_406619531457_2/a_3172_n44#
+ comp018green_esd_clamp_v5p0_DVDD_0/nmos_clamp_20_50_4_DVDD_0/nmos_6p0_CDNS_406619531457_2/a_4148_n44#
+ comp018green_esd_clamp_v5p0_DVDD_0/pmos_6p0_CDNS_406619531455_0/a_1220_n44# comp018green_esd_clamp_v5p0_DVDD_0/nmos_clamp_20_50_4_DVDD_0/nmos_6p0_CDNS_406619531457_0/a_2196_n44#
+ comp018green_esd_clamp_v5p0_DVDD_0/nmos_6p0_CDNS_406619531458_0/D comp018green_esd_clamp_v5p0_DVDD_0/nmos_6p0_CDNS_406619531458_1/a_488_n44#
+ comp018green_esd_clamp_v5p0_DVDD_0/nmos_clamp_20_50_4_DVDD_0/nmos_6p0_CDNS_406619531457_3/a_2928_n44#
+ comp018green_esd_clamp_v5p0_DVDD_0/nmos_clamp_20_50_4_DVDD_0/nmos_6p0_CDNS_406619531457_3/a_1952_n44#
+ comp018green_esd_clamp_v5p0_DVDD_0/nmos_clamp_20_50_4_DVDD_0/nmos_6p0_CDNS_406619531457_0/a_244_n44#
+ comp018green_esd_clamp_v5p0_DVDD_0/nmos_clamp_20_50_4_DVDD_0/nmos_6p0_CDNS_406619531457_2/a_1708_n44#
+ comp018green_esd_clamp_v5p0_DVDD_0/nmos_clamp_20_50_4_DVDD_0/nmos_6p0_CDNS_406619531457_3/a_4148_n44#
+ comp018green_esd_clamp_v5p0_DVDD_0/nmos_clamp_20_50_4_DVDD_0/nmos_6p0_CDNS_406619531457_3/a_3172_n44#
+ comp018green_esd_clamp_v5p0_DVDD_0/pmos_6p0_CDNS_406619531455_0/a_1464_n44# comp018green_esd_clamp_v5p0_DVDD_0/nmos_clamp_20_50_4_DVDD_0/nmos_6p0_CDNS_406619531457_1/a_2196_n44#
+ comp018green_esd_clamp_v5p0_DVDD_0/nmos_6p0_CDNS_406619531459_0/a_0_n44# comp018green_esd_clamp_v5p0_DVDD_0/M1_POLY2_CDNS_40661953145109_0/a_n653_n42#
+ comp018green_esd_clamp_v5p0_DVDD_0/nmos_clamp_20_50_4_DVDD_0/nmos_6p0_CDNS_406619531457_0/a_488_n44#
+ comp018green_esd_clamp_v5p0_DVDD_0/nmos_clamp_20_50_4_DVDD_0/nmos_6p0_CDNS_406619531457_3/a_1708_n44#
+ comp018green_esd_clamp_v5p0_DVDD_0/nmos_clamp_20_50_4_DVDD_0/nmos_6p0_CDNS_406619531457_2/a_2196_n44#
+ comp018green_esd_clamp_v5p0_DVDD_0/M1_POLY2_CDNS_40661953145109_1/a_n653_n42# comp018green_esd_clamp_v5p0_DVDD_0/nmos_clamp_20_50_4_DVDD_0/nmos_6p0_CDNS_406619531457_3/a_2196_n44#
+ comp018green_esd_clamp_v5p0_DVDD_0/pmos_6p0_CDNS_406619531456_0/a_0_n44# comp018green_esd_clamp_v5p0_DVDD_0/comp018green_esd_rc_v5p0_0/ppolyf_u_CDNS_406619531453_9/PLUS
+ comp018green_esd_clamp_v5p0_DVDD_0/nmos_clamp_20_50_4_DVDD_0/nmos_6p0_CDNS_406619531457_1/a_244_n44#
+ comp018green_esd_clamp_v5p0_DVDD_0/pmos_6p0_CDNS_406619531455_0/a_244_n44# comp018green_esd_clamp_v5p0_DVDD_0/nmos_clamp_20_50_4_DVDD_0/M2_M1_CDNS_40661953145136_6/m1_n92_n2414#
+ comp018green_esd_clamp_v5p0_DVDD_0/nmos_clamp_20_50_4_DVDD_0/nmos_6p0_CDNS_406619531457_1/a_488_n44#
+ comp018green_esd_clamp_v5p0_DVDD_0/pmos_6p0_CDNS_406619531455_0/a_488_n44# comp018green_esd_clamp_v5p0_DVDD_0/nmos_clamp_20_50_4_DVDD_0/M2_M1_CDNS_40661953145136_2/m1_n92_n2414#
+ comp018green_esd_clamp_v5p0_DVDD_0/comp018green_esd_rc_v5p0_0/ppolyf_u_CDNS_406619531453_11/PLUS
+ comp018green_esd_clamp_v5p0_DVDD_0/comp018green_esd_rc_v5p0_0/ppolyf_u_CDNS_406619531453_6/PLUS
+ comp018green_esd_clamp_v5p0_DVDD_0/comp018green_esd_rc_v5p0_0/ppolyf_u_CDNS_406619531453_0/MINUS
+ comp018green_esd_clamp_v5p0_DVDD_0/pmos_6p0_CDNS_406619531452_0/a_732_n44# comp018green_esd_clamp_v5p0_DVDD_0/nmos_clamp_20_50_4_DVDD_0/nmos_6p0_CDNS_406619531457_2/a_244_n44#
+ comp018green_esd_clamp_v5p0_DVDD_0/comp018green_esd_rc_v5p0_0/ppolyf_u_CDNS_406619531453_1/MINUS
+ M3_M2_CDNS_4066195314590_8/m2_n906_n658# comp018green_esd_clamp_v5p0_DVDD_0/nmos_clamp_20_50_4_DVDD_0/nmos_6p0_CDNS_406619531457_2/a_488_n44#
+ comp018green_esd_clamp_v5p0_DVDD_0/nmos_6p0_CDNS_406619531458_0/a_1220_n44# comp018green_esd_clamp_v5p0_DVDD_0/nmos_clamp_20_50_4_DVDD_0/nmos_6p0_CDNS_406619531457_3/a_0_n44#
+ comp018green_esd_clamp_v5p0_DVDD_0/comp018green_esd_rc_v5p0_0/ppolyf_u_CDNS_406619531453_3/PLUS
+ comp018green_esd_clamp_v5p0_DVDD_0/nmos_6p0_CDNS_406619531458_1/a_0_n44# comp018green_esd_clamp_v5p0_DVDD_0/comp018green_esd_rc_v5p0_0/ppolyf_u_CDNS_406619531453_2/MINUS
+ comp018green_esd_clamp_v5p0_DVDD_0/nmos_6p0_CDNS_406619531458_1/a_1220_n44# comp018green_esd_clamp_v5p0_DVDD_0/comp018green_esd_rc_v5p0_0/ppolyf_u_CDNS_406619531453_3/MINUS
+ comp018green_esd_clamp_v5p0_DVDD_0/nmos_clamp_20_50_4_DVDD_0/nmos_6p0_CDNS_406619531457_3/a_244_n44#
+ comp018green_esd_clamp_v5p0_DVDD_0/comp018green_esd_rc_v5p0_0/ppolyf_u_CDNS_406619531453_0/PLUS
+ comp018green_esd_clamp_v5p0_DVDD_0/nmos_clamp_20_50_4_DVDD_0/nmos_6p0_CDNS_406619531457_3/a_488_n44#
+ comp018green_esd_clamp_v5p0_DVDD_0/nmos_6p0_CDNS_406619531459_0/D comp018green_esd_clamp_v5p0_DVDD_0/comp018green_esd_rc_v5p0_0/ppolyf_u_CDNS_406619531453_4/MINUS
+ M3_M2_CDNS_4066195314592_7/m2_n968_n658# comp018green_esd_clamp_v5p0_DVDD_0/comp018green_esd_rc_v5p0_0/ppolyf_u_CDNS_406619531453_10/MINUS
+ comp018green_esd_clamp_v5p0_DVDD_0/nmos_clamp_20_50_4_DVDD_0/M2_M1_CDNS_40661953145136_7/m1_n92_n2414#
+ comp018green_esd_clamp_v5p0_DVDD_0/nmos_clamp_20_50_4_DVDD_0/nmos_6p0_CDNS_406619531457_0/a_0_n44#
+ comp018green_esd_clamp_v5p0_DVDD_0/comp018green_esd_rc_v5p0_0/ppolyf_u_CDNS_406619531453_5/MINUS
+ comp018green_esd_clamp_v5p0_DVDD_0/nmos_clamp_20_50_4_DVDD_0/M2_M1_CDNS_40661953145136_0/m1_n92_n2414#
+ comp018green_esd_clamp_v5p0_DVDD_0/nmos_6p0_CDNS_406619531458_0/a_732_n44# comp018green_esd_clamp_v5p0_DVDD_0/comp018green_esd_rc_v5p0_0/ppolyf_u_CDNS_406619531453_11/MINUS
+ comp018green_esd_clamp_v5p0_DVDD_0/nmos_6p0_CDNS_406619531458_0/a_976_n44# comp018green_esd_clamp_v5p0_DVDD_0/nmos_clamp_20_50_4_DVDD_0/nmos_6p0_CDNS_406619531457_3/D
+ comp018green_esd_clamp_v5p0_DVDD_0/comp018green_esd_rc_v5p0_0/ppolyf_u_CDNS_406619531453_6/MINUS
+ comp018green_esd_clamp_v5p0_DVDD_0/nmos_clamp_20_50_4_DVDD_0/nmos_6p0_CDNS_406619531457_0/a_3660_n44#
+ comp018green_esd_clamp_v5p0_DVDD_0/nmos_clamp_20_50_4_DVDD_0/nmos_6p0_CDNS_406619531457_0/a_4636_n44#
+ comp018green_esd_clamp_v5p0_DVDD_0/comp018green_esd_rc_v5p0_0/ppolyf_u_CDNS_406619531453_7/MINUS
+ comp018green_esd_clamp_v5p0_DVDD_0/pmos_6p0_CDNS_406619531455_0/a_3904_n44# comp018green_esd_clamp_v5p0_DVDD_0/nmos_clamp_20_50_4_DVDD_0/nmos_6p0_CDNS_406619531457_1/a_4636_n44#
+ comp018green_esd_clamp_v5p0_DVDD_0/nmos_clamp_20_50_4_DVDD_0/nmos_6p0_CDNS_406619531457_1/a_3660_n44#
+ comp018green_esd_clamp_v5p0_DVDD_0/pmos_6p0_CDNS_406619531455_0/a_5124_n44# comp018green_esd_clamp_v5p0_DVDD_0/nmos_clamp_20_50_4_DVDD_0/nmos_6p0_CDNS_406619531457_0/a_3416_n44#
+ comp018green_esd_clamp_v5p0_DVDD_0/nmos_clamp_20_50_4_DVDD_0/nmos_6p0_CDNS_406619531457_0/a_2440_n44#
+ comp018green_esd_clamp_v5p0_DVDD_0/nmos_6p0_CDNS_406619531458_1/a_732_n44# comp018green_esd_clamp_v5p0_DVDD_0/nmos_clamp_20_50_4_DVDD_0/nmos_6p0_CDNS_406619531457_2/a_3660_n44#
+ comp018green_esd_clamp_v5p0_DVDD_0/comp018green_esd_rc_v5p0_0/ppolyf_u_CDNS_406619531453_8/MINUS
+ comp018green_esd_clamp_v5p0_DVDD_0/nmos_clamp_20_50_4_DVDD_0/nmos_6p0_CDNS_406619531457_2/a_4636_n44#
+ comp018green_esd_clamp_v5p0_DVDD_0/pmos_6p0_CDNS_406619531455_0/a_5368_n44# comp018green_esd_clamp_v5p0_DVDD_0/pmos_6p0_CDNS_406619531455_0/a_4392_n44#
+ comp018green_esd_clamp_v5p0_DVDD_0/nmos_clamp_20_50_4_DVDD_0/nmos_6p0_CDNS_406619531457_0/a_2684_n44#
+ comp018green_esd_clamp_v5p0_DVDD_0/nmos_clamp_20_50_4_DVDD_0/nmos_6p0_CDNS_406619531457_1/a_3416_n44#
+ comp018green_esd_clamp_v5p0_DVDD_0/nmos_clamp_20_50_4_DVDD_0/nmos_6p0_CDNS_406619531457_1/a_2440_n44#
+ comp018green_esd_clamp_v5p0_DVDD_0/nmos_6p0_CDNS_406619531458_1/a_976_n44# comp018green_esd_clamp_v5p0_DVDD_0/comp018green_esd_rc_v5p0_0/ppolyf_u_CDNS_406619531453_7/PLUS
+ comp018green_esd_clamp_v5p0_DVDD_0/nmos_clamp_20_50_4_DVDD_0/nmos_6p0_CDNS_406619531457_0/a_1220_n44#
+ comp018green_esd_clamp_v5p0_DVDD_0/nmos_clamp_20_50_4_DVDD_0/nmos_6p0_CDNS_406619531457_0/a_732_n44#
+ comp018green_esd_clamp_v5p0_DVDD_0/nmos_clamp_20_50_4_DVDD_0/nmos_6p0_CDNS_406619531457_3/a_4636_n44#
+ comp018green_esd_clamp_v5p0_DVDD_0/nmos_clamp_20_50_4_DVDD_0/nmos_6p0_CDNS_406619531457_3/a_3660_n44#
+ comp018green_esd_clamp_v5p0_DVDD_0/pmos_6p0_CDNS_406619531455_0/a_1952_n44# comp018green_esd_clamp_v5p0_DVDD_0/pmos_6p0_CDNS_406619531455_0/a_2928_n44#
+ comp018green_esd_clamp_v5p0_DVDD_0/nmos_clamp_20_50_4_DVDD_0/nmos_6p0_CDNS_406619531457_1/a_2684_n44#
+ comp018green_esd_clamp_v5p0_DVDD_0/nmos_clamp_20_50_4_DVDD_0/nmos_6p0_CDNS_406619531457_2/a_3416_n44#
+ comp018green_esd_clamp_v5p0_DVDD_0/nmos_clamp_20_50_4_DVDD_0/nmos_6p0_CDNS_406619531457_2/a_2440_n44#
+ comp018green_esd_clamp_v5p0_DVDD_0/pmos_6p0_CDNS_406619531455_0/a_4148_n44# comp018green_esd_clamp_v5p0_DVDD_0/pmos_6p0_CDNS_406619531455_0/a_3172_n44#
+ VSUBS comp018green_esd_clamp_v5p0_DVDD_0/nmos_clamp_20_50_4_DVDD_0/nmos_6p0_CDNS_406619531457_0/a_1464_n44#
+ comp018green_esd_clamp_v5p0_DVDD_0/nmos_clamp_20_50_4_DVDD_0/nmos_6p0_CDNS_406619531457_1/a_1220_n44#
+ comp018green_esd_clamp_v5p0_DVDD_0/comp018green_esd_rc_v5p0_0/ppolyf_u_CDNS_406619531453_9/MINUS
+ comp018green_esd_clamp_v5p0_DVDD_0/nmos_clamp_20_50_4_DVDD_0/nmos_6p0_CDNS_406619531457_0/a_976_n44#
+ M3_M2_CDNS_4066195314592_29/m2_n968_n658# comp018green_esd_clamp_v5p0_DVDD_0/nmos_clamp_20_50_4_DVDD_0/nmos_6p0_CDNS_406619531457_2/a_2684_n44#
+ comp018green_esd_clamp_v5p0_DVDD_0/nmos_clamp_20_50_4_DVDD_0/nmos_6p0_CDNS_406619531457_3/a_3416_n44#
+ comp018green_esd_clamp_v5p0_DVDD_0/nmos_clamp_20_50_4_DVDD_0/nmos_6p0_CDNS_406619531457_3/a_2440_n44#
+ comp018green_esd_clamp_v5p0_DVDD_0/pmos_6p0_CDNS_406619531455_0/a_1708_n44# comp018green_esd_clamp_v5p0_DVDD_0/nmos_clamp_20_50_4_DVDD_0/nmos_6p0_CDNS_406619531457_1/a_1464_n44#
+ comp018green_esd_clamp_v5p0_DVDD_0/nmos_clamp_20_50_4_DVDD_0/nmos_6p0_CDNS_406619531457_2/a_1220_n44#
+ M3_M2_CDNS_4066195314592_13/m2_n968_n658# comp018green_esd_clamp_v5p0_DVDD_0/nmos_clamp_20_50_4_DVDD_0/nmos_6p0_CDNS_406619531457_3/a_2684_n44#
+ comp018green_esd_clamp_v5p0_DVDD_0/nmos_clamp_20_50_4_DVDD_0/nmos_6p0_CDNS_406619531457_2/a_1464_n44#
+ comp018green_esd_clamp_v5p0_DVDD_0/nmos_clamp_20_50_4_DVDD_0/nmos_6p0_CDNS_406619531457_3/a_1220_n44#
+ comp018green_esd_clamp_v5p0_DVDD_0/nmos_clamp_20_50_4_DVDD_0/M2_M1_CDNS_40661953145136_5/m1_n92_n2414#
+ comp018green_esd_clamp_v5p0_DVDD_0/pmos_6p0_CDNS_406619531455_0/a_2196_n44# comp018green_esd_clamp_v5p0_DVDD_0/comp018green_esd_rc_v5p0_0/ppolyf_u_CDNS_406619531453_4/PLUS
+ comp018green_esd_clamp_v5p0_DVDD_0/M1_POLY2_CDNS_40661953145105_0/a_n371_n42# M3_M2_CDNS_4066195314590_8/m2_n906_n658#
+ comp018green_esd_clamp_v5p0_DVDD_0/nmos_6p0_CDNS_406619531458_1/D comp018green_esd_clamp_v5p0_DVDD_0/nmos_clamp_20_50_4_DVDD_0/M2_M1_CDNS_40661953145136_1/m1_n92_n2414#
+ comp018green_esd_clamp_v5p0_DVDD_0/nmos_clamp_20_50_4_DVDD_0/nmos_6p0_CDNS_406619531457_3/a_1464_n44#
+ comp018green_esd_clamp_v5p0_DVDD_0/nmos_clamp_20_50_4_DVDD_0/nmos_6p0_CDNS_406619531457_0/S
+ comp018green_esd_clamp_v5p0_DVDD_0/nmos_clamp_20_50_4_DVDD_0/nmos_6p0_CDNS_406619531457_1/a_732_n44#
+ comp018green_esd_clamp_v5p0_DVDD_0/pmos_6p0_CDNS_406619531455_0/a_732_n44# comp018green_esd_clamp_v5p0_DVDD_0/nmos_clamp_20_50_4_DVDD_0/nmos_6p0_CDNS_406619531457_1/a_976_n44#
+ comp018green_esd_clamp_v5p0_DVDD_0/M2_M1_CDNS_40661953145103_0/m1_n92_n92# comp018green_esd_clamp_v5p0_DVDD_0/nmos_6p0_CDNS_406619531458_1/S
+ comp018green_esd_clamp_v5p0_DVDD_0/pmos_6p0_CDNS_406619531455_0/a_976_n44# comp018green_esd_clamp_v5p0_DVDD_0/nmos_clamp_20_50_4_DVDD_0/nmos_6p0_CDNS_406619531457_1/S
+ comp018green_esd_clamp_v5p0_DVDD_0/M2_M1_CDNS_40661953145103_1/m1_n92_n92# comp018green_esd_clamp_v5p0_DVDD_0/M2_M1_CDNS_40661953145117_0/m1_n90_n38#
+ comp018green_esd_clamp_v5p0_DVDD_0/comp018green_esd_rc_v5p0_0/ppolyf_u_CDNS_406619531453_1/PLUS
+ comp018green_esd_clamp_v5p0_DVDD_0/nmos_clamp_20_50_4_DVDD_0/nmos_6p0_CDNS_406619531457_3/S
+ comp018green_esd_clamp_v5p0_DVDD_0/nmos_clamp_20_50_4_DVDD_0/nmos_6p0_CDNS_406619531457_1/a_0_n44#
+ comp018green_esd_clamp_v5p0_DVDD_0/M2_M1_CDNS_40661953145117_1/m1_n90_n38# comp018green_esd_clamp_v5p0_DVDD_0/nmos_clamp_20_50_4_DVDD_0/nmos_6p0_CDNS_406619531457_2/a_732_n44#
+ comp018green_esd_clamp_v5p0_DVDD_0/M2_M1_CDNS_40661953145117_2/m1_n90_n38# comp018green_esd_clamp_v5p0_DVDD_0/pmos_6p0_CDNS_406619531455_0/D
+ comp018green_esd_clamp_v5p0_DVDD_0/nmos_clamp_20_50_4_DVDD_0/nmos_6p0_CDNS_406619531457_2/a_976_n44#
+ comp018green_esd_clamp_v5p0_DVDD_0/pmos_6p0_CDNS_406619531456_0/S comp018green_esd_clamp_v5p0_DVDD_0/M1_POLY2_CDNS_40661953145108_0/a_n277_n42#
+ comp018green_esd_clamp_v5p0_DVDD_0/nmos_clamp_20_50_4_DVDD_0/nmos_6p0_CDNS_406619531457_3/S
+ comp018green_esd_clamp_v5p0_DVDD_0/nmos_clamp_20_50_4_DVDD_0/nmos_6p0_CDNS_406619531457_3/S
+ VSUBS VSUBS comp018green_esd_clamp_v5p0_DVDD_0/pmos_6p0_CDNS_406619531452_0/a_0_n44#
+ M3_M2_CDNS_4066195314590_8/m2_n906_n658# comp018green_esd_clamp_v5p0_DVDD
Xnp_6p0_CDNS_406619531451_0 np_6p0_CDNS_406619531451_0/MINUS VSUBS np_6p0_CDNS_406619531451
Xnp_6p0_CDNS_406619531451_1 np_6p0_CDNS_406619531451_2/MINUS VSUBS np_6p0_CDNS_406619531451
Xnp_6p0_CDNS_406619531451_2 np_6p0_CDNS_406619531451_2/MINUS VSUBS np_6p0_CDNS_406619531451
Xnp_6p0_CDNS_406619531451_3 np_6p0_CDNS_406619531451_3/MINUS VSUBS np_6p0_CDNS_406619531451
.ends

.subckt gf180mcu_fd_io__dvdd DVDD VSS
XGF_NI_DVDD_BASE_0 GF_NI_DVDD_BASE_0/comp018green_esd_clamp_v5p0_DVDD_0/pmos_6p0_CDNS_406619531455_0/D
+ GF_NI_DVDD_BASE_0/comp018green_esd_clamp_v5p0_DVDD_0/pmos_6p0_CDNS_406619531455_0/D
+ DVDD GF_NI_DVDD_BASE_0/comp018green_esd_clamp_v5p0_DVDD_0/comp018green_esd_rc_v5p0_0/ppolyf_u_CDNS_406619531453_8/PLUS
+ GF_NI_DVDD_BASE_0/comp018green_esd_clamp_v5p0_DVDD_0/pmos_6p0_CDNS_406619531455_0/D
+ GF_NI_DVDD_BASE_0/comp018green_esd_clamp_v5p0_DVDD_0/pmos_6p0_CDNS_406619531455_0/D
+ GF_NI_DVDD_BASE_0/comp018green_esd_clamp_v5p0_DVDD_0/comp018green_esd_rc_v5p0_0/ppolyf_u_CDNS_406619531453_0/MINUS
+ DVDD GF_NI_DVDD_BASE_0/comp018green_esd_clamp_v5p0_DVDD_0/pmos_6p0_CDNS_406619531455_0/D
+ DVDD GF_NI_DVDD_BASE_0/comp018green_esd_clamp_v5p0_DVDD_0/pmos_6p0_CDNS_406619531455_0/D
+ GF_NI_DVDD_BASE_0/comp018green_esd_clamp_v5p0_DVDD_0/comp018green_esd_rc_v5p0_0/ppolyf_u_CDNS_406619531453_2/MINUS
+ GF_NI_DVDD_BASE_0/comp018green_esd_clamp_v5p0_DVDD_0/comp018green_esd_rc_v5p0_0/ppolyf_u_CDNS_406619531453_8/PLUS
+ GF_NI_DVDD_BASE_0/comp018green_esd_clamp_v5p0_DVDD_0/pmos_6p0_CDNS_406619531455_0/D
+ GF_NI_DVDD_BASE_0/comp018green_esd_clamp_v5p0_DVDD_0/pmos_6p0_CDNS_406619531455_0/D
+ GF_NI_DVDD_BASE_0/comp018green_esd_clamp_v5p0_DVDD_0/pmos_6p0_CDNS_406619531455_0/D
+ GF_NI_DVDD_BASE_0/comp018green_esd_clamp_v5p0_DVDD_0/pmos_6p0_CDNS_406619531455_0/D
+ GF_NI_DVDD_BASE_0/comp018green_esd_clamp_v5p0_DVDD_0/pmos_6p0_CDNS_406619531455_0/D
+ GF_NI_DVDD_BASE_0/comp018green_esd_clamp_v5p0_DVDD_0/pmos_6p0_CDNS_406619531455_0/D
+ VSS VSS GF_NI_DVDD_BASE_0/comp018green_esd_clamp_v5p0_DVDD_0/pmos_6p0_CDNS_406619531455_0/D
+ GF_NI_DVDD_BASE_0/comp018green_esd_clamp_v5p0_DVDD_0/pmos_6p0_CDNS_406619531455_0/D
+ GF_NI_DVDD_BASE_0/comp018green_esd_clamp_v5p0_DVDD_0/pmos_6p0_CDNS_406619531455_0/D
+ GF_NI_DVDD_BASE_0/comp018green_esd_clamp_v5p0_DVDD_0/pmos_6p0_CDNS_406619531455_0/D
+ GF_NI_DVDD_BASE_0/comp018green_esd_clamp_v5p0_DVDD_0/pmos_6p0_CDNS_406619531455_0/D
+ GF_NI_DVDD_BASE_0/comp018green_esd_clamp_v5p0_DVDD_0/pmos_6p0_CDNS_406619531456_0/D
+ GF_NI_DVDD_BASE_0/comp018green_esd_clamp_v5p0_DVDD_0/pmos_6p0_CDNS_406619531455_0/D
+ GF_NI_DVDD_BASE_0/comp018green_esd_clamp_v5p0_DVDD_0/pmos_6p0_CDNS_406619531455_0/D
+ GF_NI_DVDD_BASE_0/comp018green_esd_clamp_v5p0_DVDD_0/pmos_6p0_CDNS_406619531455_0/D
+ VSS GF_NI_DVDD_BASE_0/comp018green_esd_clamp_v5p0_DVDD_0/pmos_6p0_CDNS_406619531456_0/D
+ GF_NI_DVDD_BASE_0/comp018green_esd_clamp_v5p0_DVDD_0/comp018green_esd_rc_v5p0_0/ppolyf_u_CDNS_406619531453_3/MINUS
+ GF_NI_DVDD_BASE_0/comp018green_esd_clamp_v5p0_DVDD_0/pmos_6p0_CDNS_406619531455_0/D
+ GF_NI_DVDD_BASE_0/comp018green_esd_clamp_v5p0_DVDD_0/pmos_6p0_CDNS_406619531455_0/D
+ GF_NI_DVDD_BASE_0/comp018green_esd_clamp_v5p0_DVDD_0/pmos_6p0_CDNS_406619531455_0/D
+ GF_NI_DVDD_BASE_0/comp018green_esd_clamp_v5p0_DVDD_0/pmos_6p0_CDNS_406619531452_0/D
+ GF_NI_DVDD_BASE_0/comp018green_esd_clamp_v5p0_DVDD_0/comp018green_esd_rc_v5p0_0/ppolyf_u_CDNS_406619531453_1/PLUS
+ GF_NI_DVDD_BASE_0/comp018green_esd_clamp_v5p0_DVDD_0/pmos_6p0_CDNS_406619531455_0/D
+ GF_NI_DVDD_BASE_0/comp018green_esd_clamp_v5p0_DVDD_0/pmos_6p0_CDNS_406619531455_0/D
+ GF_NI_DVDD_BASE_0/comp018green_esd_clamp_v5p0_DVDD_0/pmos_6p0_CDNS_406619531455_0/D
+ GF_NI_DVDD_BASE_0/comp018green_esd_clamp_v5p0_DVDD_0/pmos_6p0_CDNS_406619531455_0/D
+ GF_NI_DVDD_BASE_0/comp018green_esd_clamp_v5p0_DVDD_0/pmos_6p0_CDNS_406619531455_0/D
+ GF_NI_DVDD_BASE_0/comp018green_esd_clamp_v5p0_DVDD_0/pmos_6p0_CDNS_406619531455_0/D
+ GF_NI_DVDD_BASE_0/comp018green_esd_clamp_v5p0_DVDD_0/comp018green_esd_rc_v5p0_0/ppolyf_u_CDNS_406619531453_9/PLUS
+ GF_NI_DVDD_BASE_0/comp018green_esd_clamp_v5p0_DVDD_0/pmos_6p0_CDNS_406619531455_0/D
+ GF_NI_DVDD_BASE_0/comp018green_esd_clamp_v5p0_DVDD_0/pmos_6p0_CDNS_406619531455_0/D
+ GF_NI_DVDD_BASE_0/comp018green_esd_clamp_v5p0_DVDD_0/comp018green_esd_rc_v5p0_0/ppolyf_u_CDNS_406619531453_5/PLUS
+ DVDD GF_NI_DVDD_BASE_0/comp018green_esd_clamp_v5p0_DVDD_0/pmos_6p0_CDNS_406619531455_0/D
+ GF_NI_DVDD_BASE_0/comp018green_esd_clamp_v5p0_DVDD_0/pmos_6p0_CDNS_406619531455_0/D
+ GF_NI_DVDD_BASE_0/comp018green_esd_clamp_v5p0_DVDD_0/pmos_6p0_CDNS_406619531455_0/D
+ DVDD GF_NI_DVDD_BASE_0/comp018green_esd_clamp_v5p0_DVDD_0/pmos_6p0_CDNS_406619531456_0/D
+ GF_NI_DVDD_BASE_0/comp018green_esd_clamp_v5p0_DVDD_0/pmos_6p0_CDNS_406619531456_0/D
+ GF_NI_DVDD_BASE_0/comp018green_esd_clamp_v5p0_DVDD_0/comp018green_esd_rc_v5p0_0/ppolyf_u_CDNS_406619531453_4/PLUS
+ GF_NI_DVDD_BASE_0/comp018green_esd_clamp_v5p0_DVDD_0/pmos_6p0_CDNS_406619531455_0/D
+ GF_NI_DVDD_BASE_0/comp018green_esd_clamp_v5p0_DVDD_0/pmos_6p0_CDNS_406619531455_0/D
+ GF_NI_DVDD_BASE_0/comp018green_esd_clamp_v5p0_DVDD_0/pmos_6p0_CDNS_406619531455_0/D
+ GF_NI_DVDD_BASE_0/comp018green_esd_clamp_v5p0_DVDD_0/comp018green_esd_rc_v5p0_0/ppolyf_u_CDNS_406619531453_7/PLUS
+ GF_NI_DVDD_BASE_0/comp018green_esd_clamp_v5p0_DVDD_0/pmos_6p0_CDNS_406619531455_0/D
+ VSS GF_NI_DVDD_BASE_0/comp018green_esd_clamp_v5p0_DVDD_0/pmos_6p0_CDNS_406619531452_0/D
+ GF_NI_DVDD_BASE_0/comp018green_esd_clamp_v5p0_DVDD_0/comp018green_esd_rc_v5p0_0/ppolyf_u_CDNS_406619531453_0/MINUS
+ DVDD GF_NI_DVDD_BASE_0/comp018green_esd_clamp_v5p0_DVDD_0/pmos_6p0_CDNS_406619531455_0/D
+ GF_NI_DVDD_BASE_0/comp018green_esd_clamp_v5p0_DVDD_0/pmos_6p0_CDNS_406619531456_0/D
+ GF_NI_DVDD_BASE_0/comp018green_esd_clamp_v5p0_DVDD_0/comp018green_esd_rc_v5p0_0/ppolyf_u_CDNS_406619531453_2/PLUS
+ GF_NI_DVDD_BASE_0/comp018green_esd_clamp_v5p0_DVDD_0/comp018green_esd_rc_v5p0_0/ppolyf_u_CDNS_406619531453_2/PLUS
+ GF_NI_DVDD_BASE_0/comp018green_esd_clamp_v5p0_DVDD_0/pmos_6p0_CDNS_406619531456_0/D
+ GF_NI_DVDD_BASE_0/comp018green_esd_clamp_v5p0_DVDD_0/comp018green_esd_rc_v5p0_0/ppolyf_u_CDNS_406619531453_3/PLUS
+ GF_NI_DVDD_BASE_0/comp018green_esd_clamp_v5p0_DVDD_0/pmos_6p0_CDNS_406619531455_0/D
+ GF_NI_DVDD_BASE_0/comp018green_esd_clamp_v5p0_DVDD_0/pmos_6p0_CDNS_406619531452_0/D
+ DVDD DVDD GF_NI_DVDD_BASE_0/comp018green_esd_clamp_v5p0_DVDD_0/pmos_6p0_CDNS_406619531455_0/D
+ VSS DVDD GF_NI_DVDD_BASE_0/comp018green_esd_clamp_v5p0_DVDD_0/comp018green_esd_rc_v5p0_0/ppolyf_u_CDNS_406619531453_0/PLUS
+ VSS GF_NI_DVDD_BASE_0/comp018green_esd_clamp_v5p0_DVDD_0/pmos_6p0_CDNS_406619531456_0/D
+ GF_NI_DVDD_BASE_0/comp018green_esd_clamp_v5p0_DVDD_0/pmos_6p0_CDNS_406619531452_0/D
+ VSS GF_NI_DVDD_BASE_0/comp018green_esd_clamp_v5p0_DVDD_0/pmos_6p0_CDNS_406619531456_0/D
+ GF_NI_DVDD_BASE_0/comp018green_esd_clamp_v5p0_DVDD_0/pmos_6p0_CDNS_406619531452_0/D
+ GF_NI_DVDD_BASE_0/comp018green_esd_clamp_v5p0_DVDD_0/comp018green_esd_rc_v5p0_0/ppolyf_u_CDNS_406619531453_5/PLUS
+ GF_NI_DVDD_BASE_0/comp018green_esd_clamp_v5p0_DVDD_0/pmos_6p0_CDNS_406619531452_0/D
+ GF_NI_DVDD_BASE_0/comp018green_esd_clamp_v5p0_DVDD_0/pmos_6p0_CDNS_406619531455_0/D
+ GF_NI_DVDD_BASE_0/comp018green_esd_clamp_v5p0_DVDD_0/pmos_6p0_CDNS_406619531456_0/D
+ GF_NI_DVDD_BASE_0/comp018green_esd_clamp_v5p0_DVDD_0/pmos_6p0_CDNS_406619531456_0/D
+ GF_NI_DVDD_BASE_0/comp018green_esd_clamp_v5p0_DVDD_0/pmos_6p0_CDNS_406619531456_0/D
+ DVDD GF_NI_DVDD_BASE_0/comp018green_esd_clamp_v5p0_DVDD_0/pmos_6p0_CDNS_406619531455_0/D
+ GF_NI_DVDD_BASE_0/comp018green_esd_clamp_v5p0_DVDD_0/pmos_6p0_CDNS_406619531455_0/D
+ GF_NI_DVDD_BASE_0/comp018green_esd_clamp_v5p0_DVDD_0/pmos_6p0_CDNS_406619531456_0/D
+ GF_NI_DVDD_BASE_0/comp018green_esd_clamp_v5p0_DVDD_0/pmos_6p0_CDNS_406619531456_0/D
+ DVDD GF_NI_DVDD_BASE_0/comp018green_esd_clamp_v5p0_DVDD_0/pmos_6p0_CDNS_406619531456_0/D
+ GF_NI_DVDD_BASE_0/comp018green_esd_clamp_v5p0_DVDD_0/pmos_6p0_CDNS_406619531456_0/D
+ VSS GF_NI_DVDD_BASE_0/comp018green_esd_clamp_v5p0_DVDD_0/pmos_6p0_CDNS_406619531456_0/D
+ GF_NI_DVDD_BASE_0/comp018green_esd_clamp_v5p0_DVDD_0/comp018green_esd_rc_v5p0_0/ppolyf_u_CDNS_406619531453_9/PLUS
+ GF_NI_DVDD_BASE_0/comp018green_esd_clamp_v5p0_DVDD_0/pmos_6p0_CDNS_406619531452_0/D
+ GF_NI_DVDD_BASE_0/comp018green_esd_clamp_v5p0_DVDD_0/pmos_6p0_CDNS_406619531456_0/D
+ DVDD DVDD DVDD GF_NI_DVDD_BASE_0/comp018green_esd_clamp_v5p0_DVDD_0/pmos_6p0_CDNS_406619531456_0/D
+ GF_NI_DVDD_BASE_0/comp018green_esd_clamp_v5p0_DVDD_0/pmos_6p0_CDNS_406619531455_0/D
+ GF_NI_DVDD_BASE_0/comp018green_esd_clamp_v5p0_DVDD_0/pmos_6p0_CDNS_406619531455_0/D
+ GF_NI_DVDD_BASE_0/comp018green_esd_clamp_v5p0_DVDD_0/pmos_6p0_CDNS_406619531455_0/D
+ GF_NI_DVDD_BASE_0/comp018green_esd_clamp_v5p0_DVDD_0/pmos_6p0_CDNS_406619531456_0/D
+ DVDD DVDD GF_NI_DVDD_BASE_0/comp018green_esd_clamp_v5p0_DVDD_0/pmos_6p0_CDNS_406619531455_0/D
+ VSS DVDD GF_NI_DVDD_BASE_0/comp018green_esd_clamp_v5p0_DVDD_0/pmos_6p0_CDNS_406619531455_0/D
+ VSS VSS VSS DVDD VSS DVDD GF_NI_DVDD_BASE_0/comp018green_esd_clamp_v5p0_DVDD_0/pmos_6p0_CDNS_406619531455_0/D
+ GF_NI_DVDD_BASE_0/comp018green_esd_clamp_v5p0_DVDD_0/comp018green_esd_rc_v5p0_0/ppolyf_u_CDNS_406619531453_3/PLUS
+ GF_NI_DVDD_BASE_0/comp018green_esd_clamp_v5p0_DVDD_0/pmos_6p0_CDNS_406619531455_0/D
+ GF_NI_DVDD_BASE_0/comp018green_esd_clamp_v5p0_DVDD_0/pmos_6p0_CDNS_406619531455_0/D
+ GF_NI_DVDD_BASE_0/comp018green_esd_clamp_v5p0_DVDD_0/pmos_6p0_CDNS_406619531455_0/D
+ GF_NI_DVDD_BASE_0/comp018green_esd_clamp_v5p0_DVDD_0/pmos_6p0_CDNS_406619531455_0/D
+ VSS DVDD GF_NI_DVDD_BASE_0/comp018green_esd_clamp_v5p0_DVDD_0/pmos_6p0_CDNS_406619531455_0/D
+ GF_NI_DVDD_BASE_0/comp018green_esd_clamp_v5p0_DVDD_0/pmos_6p0_CDNS_406619531455_0/D
+ GF_NI_DVDD_BASE_0/comp018green_esd_clamp_v5p0_DVDD_0/pmos_6p0_CDNS_406619531455_0/D
+ GF_NI_DVDD_BASE_0/comp018green_esd_clamp_v5p0_DVDD_0/pmos_6p0_CDNS_406619531456_0/D
+ GF_NI_DVDD_BASE_0/comp018green_esd_clamp_v5p0_DVDD_0/pmos_6p0_CDNS_406619531455_0/D
+ GF_NI_DVDD_BASE_0/comp018green_esd_clamp_v5p0_DVDD_0/pmos_6p0_CDNS_406619531455_0/D
+ DVDD GF_NI_DVDD_BASE_0/comp018green_esd_clamp_v5p0_DVDD_0/pmos_6p0_CDNS_406619531455_0/D
+ GF_NI_DVDD_BASE_0/comp018green_esd_clamp_v5p0_DVDD_0/pmos_6p0_CDNS_406619531455_0/D
+ GF_NI_DVDD_BASE_0/comp018green_esd_clamp_v5p0_DVDD_0/comp018green_esd_rc_v5p0_0/ppolyf_u_CDNS_406619531453_0/MINUS
+ DVDD GF_NI_DVDD_BASE_0/comp018green_esd_clamp_v5p0_DVDD_0/pmos_6p0_CDNS_406619531455_0/D
+ GF_NI_DVDD_BASE_0/comp018green_esd_clamp_v5p0_DVDD_0/pmos_6p0_CDNS_406619531455_0/D
+ GF_NI_DVDD_BASE_0/comp018green_esd_clamp_v5p0_DVDD_0/pmos_6p0_CDNS_406619531455_0/D
+ VSS GF_NI_DVDD_BASE_0/comp018green_esd_clamp_v5p0_DVDD_0/pmos_6p0_CDNS_406619531455_0/D
+ VSS GF_NI_DVDD_BASE_0/comp018green_esd_clamp_v5p0_DVDD_0/pmos_6p0_CDNS_406619531455_0/D
+ GF_NI_DVDD_BASE_0/comp018green_esd_clamp_v5p0_DVDD_0/pmos_6p0_CDNS_406619531455_0/D
+ GF_NI_DVDD_BASE_0/comp018green_esd_clamp_v5p0_DVDD_0/comp018green_esd_rc_v5p0_0/ppolyf_u_CDNS_406619531453_0/PLUS
+ GF_NI_DVDD_BASE_0/comp018green_esd_clamp_v5p0_DVDD_0/comp018green_esd_rc_v5p0_0/ppolyf_u_CDNS_406619531453_0/MINUS
+ GF_NI_DVDD_BASE_0/comp018green_esd_clamp_v5p0_DVDD_0/pmos_6p0_CDNS_406619531455_0/D
+ GF_NI_DVDD_BASE_0/comp018green_esd_clamp_v5p0_DVDD_0/pmos_6p0_CDNS_406619531455_0/D
+ GF_NI_DVDD_BASE_0/comp018green_esd_clamp_v5p0_DVDD_0/pmos_6p0_CDNS_406619531455_0/D
+ VSS DVDD GF_NI_DVDD_BASE_0/comp018green_esd_clamp_v5p0_DVDD_0/pmos_6p0_CDNS_406619531455_0/D
+ GF_NI_DVDD_BASE_0/comp018green_esd_clamp_v5p0_DVDD_0/pmos_6p0_CDNS_406619531455_0/D
+ GF_NI_DVDD_BASE_0/comp018green_esd_clamp_v5p0_DVDD_0/pmos_6p0_CDNS_406619531455_0/D
+ DVDD GF_NI_DVDD_BASE_0/comp018green_esd_clamp_v5p0_DVDD_0/pmos_6p0_CDNS_406619531455_0/D
+ VSS DVDD DVDD GF_NI_DVDD_BASE_0/comp018green_esd_clamp_v5p0_DVDD_0/pmos_6p0_CDNS_406619531455_0/D
+ GF_NI_DVDD_BASE_0/comp018green_esd_clamp_v5p0_DVDD_0/pmos_6p0_CDNS_406619531455_0/D
+ GF_NI_DVDD_BASE_0/comp018green_esd_clamp_v5p0_DVDD_0/pmos_6p0_CDNS_406619531455_0/D
+ GF_NI_DVDD_BASE_0/comp018green_esd_clamp_v5p0_DVDD_0/pmos_6p0_CDNS_406619531455_0/D
+ GF_NI_DVDD_BASE_0/comp018green_esd_clamp_v5p0_DVDD_0/pmos_6p0_CDNS_406619531455_0/D
+ GF_NI_DVDD_BASE_0/comp018green_esd_clamp_v5p0_DVDD_0/pmos_6p0_CDNS_406619531455_0/D
+ GF_NI_DVDD_BASE_0/comp018green_esd_clamp_v5p0_DVDD_0/pmos_6p0_CDNS_406619531455_0/D
+ GF_NI_DVDD_BASE_0/comp018green_esd_clamp_v5p0_DVDD_0/pmos_6p0_CDNS_406619531455_0/D
+ GF_NI_DVDD_BASE_0/comp018green_esd_clamp_v5p0_DVDD_0/comp018green_esd_rc_v5p0_0/ppolyf_u_CDNS_406619531453_0/MINUS
+ GF_NI_DVDD_BASE_0/comp018green_esd_clamp_v5p0_DVDD_0/comp018green_esd_rc_v5p0_0/ppolyf_u_CDNS_406619531453_3/MINUS
+ VSS GF_NI_DVDD_BASE_0/comp018green_esd_clamp_v5p0_DVDD_0/pmos_6p0_CDNS_406619531455_0/D
+ GF_NI_DVDD_BASE_0/comp018green_esd_clamp_v5p0_DVDD_0/pmos_6p0_CDNS_406619531455_0/D
+ VSS DVDD VSS GF_NI_DVDD_BASE_0/comp018green_esd_clamp_v5p0_DVDD_0/pmos_6p0_CDNS_406619531455_0/D
+ VSS DVDD DVDD DVDD GF_NI_DVDD_BASE_0/comp018green_esd_clamp_v5p0_DVDD_0/pmos_6p0_CDNS_406619531455_0/D
+ GF_NI_DVDD_BASE_0/comp018green_esd_clamp_v5p0_DVDD_0/pmos_6p0_CDNS_406619531455_0/D
+ GF_NI_DVDD_BASE_0/comp018green_esd_clamp_v5p0_DVDD_0/pmos_6p0_CDNS_406619531455_0/D
+ GF_NI_DVDD_BASE_0/comp018green_esd_clamp_v5p0_DVDD_0/pmos_6p0_CDNS_406619531456_0/D
+ GF_NI_DVDD_BASE_0/comp018green_esd_clamp_v5p0_DVDD_0/pmos_6p0_CDNS_406619531452_0/D
+ GF_NI_DVDD_BASE_0/comp018green_esd_clamp_v5p0_DVDD_0/pmos_6p0_CDNS_406619531455_0/D
+ GF_NI_DVDD_BASE_0/comp018green_esd_clamp_v5p0_DVDD_0/comp018green_esd_rc_v5p0_0/ppolyf_u_CDNS_406619531453_7/PLUS
+ VSS GF_NI_DVDD_BASE_0/comp018green_esd_clamp_v5p0_DVDD_0/pmos_6p0_CDNS_406619531456_0/D
+ GF_NI_DVDD_BASE_0/comp018green_esd_clamp_v5p0_DVDD_0/pmos_6p0_CDNS_406619531456_0/D
+ GF_NI_DVDD_BASE_0/comp018green_esd_clamp_v5p0_DVDD_0/pmos_6p0_CDNS_406619531452_0/D
+ GF_NI_DVDD_BASE_0/comp018green_esd_clamp_v5p0_DVDD_0/comp018green_esd_rc_v5p0_0/ppolyf_u_CDNS_406619531453_0/MINUS
+ DVDD DVDD GF_NI_DVDD_BASE_0/comp018green_esd_clamp_v5p0_DVDD_0/pmos_6p0_CDNS_406619531456_0/D
+ DVDD DVDD GF_NI_DVDD_BASE_0/comp018green_esd_clamp_v5p0_DVDD_0/pmos_6p0_CDNS_406619531452_0/D
+ DVDD GF_NI_DVDD_BASE_0/comp018green_esd_clamp_v5p0_DVDD_0/pmos_6p0_CDNS_406619531452_0/D
+ GF_NI_DVDD_BASE_0/comp018green_esd_clamp_v5p0_DVDD_0/pmos_6p0_CDNS_406619531456_0/D
+ GF_NI_DVDD_BASE_0/comp018green_esd_clamp_v5p0_DVDD_0/pmos_6p0_CDNS_406619531456_0/D
+ DVDD VSS DVDD GF_NI_DVDD_BASE_0/comp018green_esd_clamp_v5p0_DVDD_0/comp018green_esd_rc_v5p0_0/ppolyf_u_CDNS_406619531453_4/PLUS
+ DVDD GF_NI_DVDD_BASE_0/comp018green_esd_clamp_v5p0_DVDD_0/pmos_6p0_CDNS_406619531456_0/D
+ GF_NI_DVDD_BASE_0/comp018green_esd_clamp_v5p0_DVDD_0/pmos_6p0_CDNS_406619531456_0/D
+ GF_NI_DVDD_BASE_0/comp018green_esd_clamp_v5p0_DVDD_0/pmos_6p0_CDNS_406619531452_0/D
+ GF_NI_DVDD_BASE_0/comp018green_esd_clamp_v5p0_DVDD_0/pmos_6p0_CDNS_406619531456_0/D
+ GF_NI_DVDD_BASE_0/comp018green_esd_clamp_v5p0_DVDD_0/pmos_6p0_CDNS_406619531452_0/D
+ GF_NI_DVDD_BASE_0/comp018green_esd_clamp_v5p0_DVDD_0/pmos_6p0_CDNS_406619531456_0/D
+ DVDD GF_NI_DVDD_BASE_0/comp018green_esd_clamp_v5p0_DVDD_0/comp018green_esd_rc_v5p0_0/ppolyf_u_CDNS_406619531453_0/MINUS
+ DVDD DVDD DVDD GF_NI_DVDD_BASE_0/comp018green_esd_clamp_v5p0_DVDD_0/pmos_6p0_CDNS_406619531456_0/D
+ GF_NI_DVDD_BASE_0/comp018green_esd_clamp_v5p0_DVDD_0/comp018green_esd_rc_v5p0_0/ppolyf_u_CDNS_406619531453_1/PLUS
+ VSS GF_NI_DVDD_BASE_0/comp018green_esd_clamp_v5p0_DVDD_0/pmos_6p0_CDNS_406619531455_0/D
+ DVDD VSS GF_NI_DVDD_BASE_0/comp018green_esd_clamp_v5p0_DVDD_0/pmos_6p0_CDNS_406619531456_0/D
+ GF_NI_DVDD_BASE_0/comp018green_esd_clamp_v5p0_DVDD_0/pmos_6p0_CDNS_406619531455_0/D
+ GF_NI_DVDD_BASE_0/comp018green_esd_clamp_v5p0_DVDD_0/pmos_6p0_CDNS_406619531456_0/D
+ GF_NI_DVDD_BASE_0/comp018green_esd_clamp_v5p0_DVDD_0/comp018green_esd_rc_v5p0_0/ppolyf_u_CDNS_406619531453_2/MINUS
+ DVDD DVDD GF_NI_DVDD_BASE_0/comp018green_esd_clamp_v5p0_DVDD_0/pmos_6p0_CDNS_406619531456_0/D
+ GF_NI_DVDD_BASE_0/comp018green_esd_clamp_v5p0_DVDD_0/comp018green_esd_rc_v5p0_0/ppolyf_u_CDNS_406619531453_0/MINUS
+ DVDD DVDD GF_NI_DVDD_BASE_0/comp018green_esd_clamp_v5p0_DVDD_0/pmos_6p0_CDNS_406619531455_0/D
+ VSS VSS GF_NI_DVDD_BASE
X0 DVDD VSS cap_nmos_06v0 c_width=15u c_length=15u
X1 DVDD VSS cap_nmos_06v0 c_width=15u c_length=15u
X2 DVDD VSS cap_nmos_06v0 c_width=15u c_length=15u
X3 GF_NI_DVDD_BASE_0/comp018green_esd_clamp_v5p0_DVDD_0/comp018green_esd_rc_v5p0_0/ppolyf_u_CDNS_406619531453_0/MINUS VSS cap_nmos_06v0 c_width=25u c_length=10u
X4 GF_NI_DVDD_BASE_0/comp018green_esd_clamp_v5p0_DVDD_0/comp018green_esd_rc_v5p0_0/ppolyf_u_CDNS_406619531453_0/MINUS VSS cap_nmos_06v0 c_width=25u c_length=10u
X5 GF_NI_DVDD_BASE_0/comp018green_esd_clamp_v5p0_DVDD_0/comp018green_esd_rc_v5p0_0/ppolyf_u_CDNS_406619531453_0/MINUS VSS cap_nmos_06v0 c_width=25u c_length=10u
X6 GF_NI_DVDD_BASE_0/comp018green_esd_clamp_v5p0_DVDD_0/comp018green_esd_rc_v5p0_0/ppolyf_u_CDNS_406619531453_0/MINUS VSS cap_nmos_06v0 c_width=25u c_length=10u
X7 GF_NI_DVDD_BASE_0/comp018green_esd_clamp_v5p0_DVDD_0/comp018green_esd_rc_v5p0_0/ppolyf_u_CDNS_406619531453_0/MINUS VSS cap_nmos_06v0 c_width=25u c_length=10u
X8 GF_NI_DVDD_BASE_0/comp018green_esd_clamp_v5p0_DVDD_0/comp018green_esd_rc_v5p0_0/ppolyf_u_CDNS_406619531453_0/MINUS VSS cap_nmos_06v0 c_width=25u c_length=10u
X9 GF_NI_DVDD_BASE_0/comp018green_esd_clamp_v5p0_DVDD_0/comp018green_esd_rc_v5p0_0/ppolyf_u_CDNS_406619531453_0/MINUS VSS cap_nmos_06v0 c_width=25u c_length=10u
X10 GF_NI_DVDD_BASE_0/comp018green_esd_clamp_v5p0_DVDD_0/comp018green_esd_rc_v5p0_0/ppolyf_u_CDNS_406619531453_0/MINUS VSS cap_nmos_06v0 c_width=25u c_length=10u
X11 DVDD VSS cap_nmos_06v0 c_width=15u c_length=15u
.ends

.subckt gf180mcu_fd_io__fill10 DVSS DVDD VDD VSS
X0 VDD VSS cap_nmos_06v0 c_width=7u c_length=6u
X1 VDD VSS cap_nmos_06v0 c_width=7u c_length=6u
X2 VDD VSS cap_nmos_06v0 c_width=7u c_length=6u
X3 VDD VSS cap_nmos_06v0 c_width=7u c_length=6u
X4 VDD VSS cap_nmos_06v0 c_width=7u c_length=6u
X5 VDD VSS cap_nmos_06v0 c_width=7u c_length=6u
X6 VDD VSS cap_nmos_06v0 c_width=7u c_length=6u
X7 VDD VSS cap_nmos_06v0 c_width=7u c_length=6u
X8 VDD VSS cap_nmos_06v0 c_width=7u c_length=6u
X9 VDD VSS cap_nmos_06v0 c_width=7u c_length=6u
X10 VDD VSS cap_nmos_06v0 c_width=7u c_length=6u
X11 VDD VSS cap_nmos_06v0 c_width=7u c_length=6u
X12 VDD VSS cap_nmos_06v0 c_width=7u c_length=6u
X13 VDD VSS cap_nmos_06v0 c_width=7u c_length=6u
X14 VDD VSS cap_nmos_06v0 c_width=7u c_length=6u
X15 VDD VSS cap_nmos_06v0 c_width=7u c_length=6u
X16 VDD VSS cap_nmos_06v0 c_width=7u c_length=6u
X17 VDD VSS cap_nmos_06v0 c_width=7u c_length=6u
X18 VDD VSS cap_nmos_06v0 c_width=7u c_length=6u
X19 VDD VSS cap_nmos_06v0 c_width=7u c_length=6u
X20 VDD VSS cap_nmos_06v0 c_width=7u c_length=6u
X21 VDD VSS cap_nmos_06v0 c_width=7u c_length=6u
X22 VDD VSS cap_nmos_06v0 c_width=7u c_length=6u
X23 VDD VSS cap_nmos_06v0 c_width=7u c_length=6u
X24 VDD VSS cap_nmos_06v0 c_width=7u c_length=6u
X25 VDD VSS cap_nmos_06v0 c_width=7u c_length=6u
X26 VDD VSS cap_nmos_06v0 c_width=7u c_length=6u
X27 VDD VSS cap_nmos_06v0 c_width=7u c_length=6u
X28 VDD VSS cap_nmos_06v0 c_width=7u c_length=6u
X29 VDD VSS cap_nmos_06v0 c_width=7u c_length=6u
X30 VDD VSS cap_nmos_06v0 c_width=7u c_length=6u
X31 VDD VSS cap_nmos_06v0 c_width=7u c_length=6u
.ends

.subckt pn_6p0_CDNS_4066195314552 w_n120_n120# PLUS
D0 PLUS w_n120_n120# diode_pd2nw_06v0 pj=0.106m area=0.15n
.ends

.subckt np_6p0_CDNS_4066195314553 MINUS VSUBS
D0 VSUBS MINUS diode_nd2ps_06v0 pj=0.106m area=0.15n
.ends

.subckt comp018green_esd_hbm pn_6p0_CDNS_4066195314552_1/PLUS pn_6p0_CDNS_4066195314552_2/PLUS
+ pn_6p0_CDNS_4066195314552_3/PLUS pn_6p0_CDNS_4066195314552_0/PLUS np_6p0_CDNS_4066195314553_0/MINUS
+ np_6p0_CDNS_4066195314553_1/MINUS np_6p0_CDNS_4066195314553_2/MINUS np_6p0_CDNS_4066195314553_3/MINUS
+ M2_M1_CDNS_40661953145413_9/m1_n224_n224# VSUBS pn_6p0_CDNS_4066195314552_3/w_n120_n120#
Xpn_6p0_CDNS_4066195314552_0 pn_6p0_CDNS_4066195314552_3/w_n120_n120# pn_6p0_CDNS_4066195314552_0/PLUS
+ pn_6p0_CDNS_4066195314552
Xpn_6p0_CDNS_4066195314552_1 pn_6p0_CDNS_4066195314552_3/w_n120_n120# pn_6p0_CDNS_4066195314552_1/PLUS
+ pn_6p0_CDNS_4066195314552
Xpn_6p0_CDNS_4066195314552_2 pn_6p0_CDNS_4066195314552_3/w_n120_n120# pn_6p0_CDNS_4066195314552_2/PLUS
+ pn_6p0_CDNS_4066195314552
Xpn_6p0_CDNS_4066195314552_3 pn_6p0_CDNS_4066195314552_3/w_n120_n120# pn_6p0_CDNS_4066195314552_3/PLUS
+ pn_6p0_CDNS_4066195314552
Xnp_6p0_CDNS_4066195314553_0 np_6p0_CDNS_4066195314553_0/MINUS VSUBS np_6p0_CDNS_4066195314553
Xnp_6p0_CDNS_4066195314553_1 np_6p0_CDNS_4066195314553_1/MINUS VSUBS np_6p0_CDNS_4066195314553
Xnp_6p0_CDNS_4066195314553_2 np_6p0_CDNS_4066195314553_2/MINUS VSUBS np_6p0_CDNS_4066195314553
Xnp_6p0_CDNS_4066195314553_3 np_6p0_CDNS_4066195314553_3/MINUS VSUBS np_6p0_CDNS_4066195314553
.ends

.subckt GF_NI_ASIG_5P0_BASE M3_M2_CDNS_4066195314596_63/m2_n224_n658# M3_M2_CDNS_4066195314598_61/m2_n224_n1464#
+ M3_M2_CDNS_4066195314594_3/m2_n100_n658# M2_M1_CDNS_40661953145151_10/m1_n38_n1496#
+ M3_M2_CDNS_4066195314596_14/m2_n224_n658# M3_M2_CDNS_4066195314596_26/m2_n224_n658#
+ M3_M2_CDNS_4066195314587_3/m2_n38_n686# M2_M1_CDNS_40661953145392_11/m1_n38_n1550#
+ M3_M2_CDNS_4066195314598_58/m2_n224_n1464# M3_M2_CDNS_4066195314596_60/m2_n224_n658#
+ M3_M2_CDNS_4066195314598_65/m2_n224_n1464# M3_M2_CDNS_4066195314596_6/m2_n224_n658#
+ M3_M2_CDNS_4066195314596_64/m2_n224_n658# M3_M2_CDNS_4066195314596_30/m2_n224_n658#
+ M3_M2_CDNS_4066195314596_52/m2_n224_n658# M2_M1_CDNS_40661953145151_13/m1_n38_n1496#
+ M3_M2_CDNS_4066195314598_40/m2_n224_n1464# M3_M2_CDNS_4066195314598_69/m2_n224_n1464#
+ M3_M2_CDNS_4066195314596_29/m2_n224_n658# M2_M1_CDNS_40661953145391_9/m1_n162_n1588#
+ M2_M1_CDNS_40661953145151_8/m1_n38_n1496# M2_M1_CDNS_40661953145392_6/m1_n38_n1550#
+ M3_M2_CDNS_4066195314596_79/m2_n224_n658# M3_M2_CDNS_4066195314596_9/m2_n224_n658#
+ M3_M2_CDNS_4066195314598_44/m2_n224_n1464# M3_M2_CDNS_4066195314596_21/m2_n224_n658#
+ M3_M2_CDNS_40661953145387_1/m2_n162_n658# M3_M2_CDNS_4066195314594_0/m2_n100_n658#
+ M3_M2_CDNS_4066195314598_51/m2_n224_n1464# M3_M2_CDNS_4066195314596_80/m2_n224_n658#
+ M3_M2_CDNS_4066195314598_48/m2_n224_n1464# comp018green_esd_hbm_0/pn_6p0_CDNS_4066195314552_2/PLUS
+ M3_M2_CDNS_4066195314587_2/m2_n38_n686# M2_M1_CDNS_40661953145389_2/m1_n100_n1588#
+ M3_M2_CDNS_4066195314596_45/m2_n224_n658# M2_M1_CDNS_40661953145392_29/m1_n38_n1550#
+ M3_M2_CDNS_4066195314596_43/m2_n224_n658# M3_M2_CDNS_4066195314596_12/m2_n224_n658#
+ M3_M2_CDNS_4066195314598_23/m2_n224_n1464# M3_M2_CDNS_4066195314596_48/m2_n224_n658#
+ M3_M2_CDNS_4066195314596_61/m2_n224_n658# M3_M2_CDNS_4066195314598_59/m2_n224_n1464#
+ M3_M2_CDNS_4066195314598_66/m2_n224_n1464# M3_M2_CDNS_4066195314596_4/m2_n224_n658#
+ M3_M2_CDNS_4066195314596_78/m2_n224_n658# M2_M1_CDNS_40661953145391_6/m1_n162_n1588#
+ M3_M2_CDNS_4066195314598_27/m2_n224_n1464# M3_M2_CDNS_4066195314596_88/m2_n224_n658#
+ M3_M2_CDNS_40661953145388_7/m2_n162_n1464# M3_M2_CDNS_4066195314596_15/m2_n224_n658#
+ M3_M2_CDNS_4066195314596_27/m2_n224_n658# M2_M1_CDNS_40661953145151_6/m1_n38_n1496#
+ M3_M2_CDNS_4066195314594_6/m2_n100_n658# M3_M2_CDNS_4066195314598_1/m2_n224_n1464#
+ M2_M1_CDNS_40661953145392_24/m1_n38_n1550# M3_M2_CDNS_4066195314596_25/m2_n224_n658#
+ M3_M2_CDNS_4066195314596_7/m2_n224_n658# M3_M2_CDNS_4066195314587_1/m2_n38_n686#
+ M2_M1_CDNS_40661953145151_5/m1_n38_n1496# M3_M2_CDNS_4066195314596_55/m2_n224_n658#
+ M3_M2_CDNS_4066195314598_5/m2_n224_n1464# M2_M1_CDNS_40661953145151_14/m1_n38_n1496#
+ M3_M2_CDNS_4066195314598_20/m2_n224_n1464# M3_M2_CDNS_4066195314596_18/m2_n224_n658#
+ M3_M2_CDNS_4066195314596_83/m2_n224_n658# M3_M2_CDNS_4066195314598_56/m2_n224_n1464#
+ M3_M2_CDNS_4066195314594_9/m2_n100_n658# M3_M2_CDNS_4066195314594_5/m2_n100_n658#
+ M3_M2_CDNS_4066195314596_75/m2_n224_n658# M3_M2_CDNS_4066195314596_44/m2_n224_n658#
+ M3_M2_CDNS_4066195314596_10/m2_n224_n658# M3_M2_CDNS_40661953145387_2/m2_n162_n658#
+ M3_M2_CDNS_4066195314596_22/m2_n224_n658# M2_M1_CDNS_40661953145391_3/m1_n162_n1588#
+ M2_M1_CDNS_40661953145151_1/m1_n38_n1496# comp018green_esd_hbm_0/pn_6p0_CDNS_4066195314552_3/PLUS
+ M3_M2_CDNS_4066195314596_46/m2_n224_n658# M2_M1_CDNS_40661953145151_17/m1_n38_n1496#
+ M3_M2_CDNS_4066195314598_35/m2_n224_n1464# comp018green_esd_hbm_0/pn_6p0_CDNS_4066195314552_0/PLUS
+ M2_M1_CDNS_40661953145392_18/m1_n38_n1550# M3_M2_CDNS_4066195314587_0/m2_n38_n686#
+ M3_M2_CDNS_4066195314596_13/m2_n224_n658# M2_M1_CDNS_40661953145151_4/m1_n38_n1496#
+ M3_M2_CDNS_4066195314594_4/m2_n100_n658# M3_M2_CDNS_4066195314598_10/m2_n224_n1464#
+ M2_M1_CDNS_40661953145392_22/m1_n38_n1550# M3_M2_CDNS_4066195314598_39/m2_n224_n1464#
+ M3_M2_CDNS_4066195314596_5/m2_n224_n658# M3_M2_CDNS_4066195314596_53/m2_n224_n658#
+ np_6p0_CDNS_406619531451_3/MINUS M3_M2_CDNS_4066195314596_77/m2_n224_n658# M3_M2_CDNS_4066195314598_60/m2_n224_n1464#
+ M3_M2_CDNS_4066195314594_2/m2_n100_n658# M3_M2_CDNS_4066195314598_6/m2_n224_n1464#
+ M2_M1_CDNS_40661953145151_12/m1_n38_n1496# M3_M2_CDNS_4066195314598_14/m2_n224_n1464#
+ M3_M2_CDNS_4066195314598_9/m2_n224_n1464# M3_M2_CDNS_4066195314596_16/m2_n224_n658#
+ comp018green_esd_hbm_0/np_6p0_CDNS_4066195314553_0/MINUS M3_M2_CDNS_4066195314596_50/m2_n224_n658#
+ M3_M2_CDNS_4066195314598_64/m2_n224_n1464# comp018green_esd_hbm_0/np_6p0_CDNS_4066195314553_1/MINUS
+ M3_M2_CDNS_4066195314596_81/m2_n224_n658# M3_M2_CDNS_4066195314596_20/m2_n224_n658#
+ M3_M2_CDNS_4066195314596_8/m2_n224_n658# M3_M2_CDNS_4066195314596_31/m2_n224_n658#
+ comp018green_esd_hbm_0/np_6p0_CDNS_4066195314553_2/MINUS M3_M2_CDNS_4066195314596_68/m2_n224_n658#
+ M3_M2_CDNS_4066195314596_0/m2_n224_n658# M3_M2_CDNS_4066195314598_68/m2_n224_n1464#
+ comp018green_esd_hbm_0/np_6p0_CDNS_4066195314553_3/MINUS M3_M2_CDNS_4066195314596_19/m2_n224_n658#
+ M3_M2_CDNS_4066195314596_89/m2_n224_n658# M3_M2_CDNS_4066195314596_67/m2_n224_n658#
+ M3_M2_CDNS_4066195314598_29/m2_n224_n1464# M3_M2_CDNS_4066195314596_74/m2_n224_n658#
+ M2_M1_CDNS_40661953145392_16/m1_n38_n1550# M2_M1_CDNS_40661953145392_8/m1_n38_n1550#
+ M3_M2_CDNS_4066195314596_11/m2_n224_n658# comp018green_esd_hbm_0/pn_6p0_CDNS_4066195314552_3/w_n120_n120#
+ M3_M2_CDNS_4066195314596_47/m2_n224_n658# M2_M1_CDNS_40661953145151_2/m1_n38_n1496#
+ comp018green_esd_hbm_0/pn_6p0_CDNS_4066195314552_1/PLUS M3_M2_CDNS_4066195314596_56/m2_n224_n658#
+ np_6p0_CDNS_406619531451_2/MINUS M3_M2_CDNS_4066195314596_3/m2_n224_n658# VSUBS
+ M3_M2_CDNS_4066195314598_47/m2_n224_n1464# M3_M2_CDNS_4066195314596_51/m2_n224_n658#
Xnp_6p0_CDNS_406619531451_0 np_6p0_CDNS_406619531451_3/MINUS VSUBS np_6p0_CDNS_406619531451
Xnp_6p0_CDNS_406619531451_1 np_6p0_CDNS_406619531451_3/MINUS VSUBS np_6p0_CDNS_406619531451
Xnp_6p0_CDNS_406619531451_2 np_6p0_CDNS_406619531451_2/MINUS VSUBS np_6p0_CDNS_406619531451
Xnp_6p0_CDNS_406619531451_3 np_6p0_CDNS_406619531451_3/MINUS VSUBS np_6p0_CDNS_406619531451
Xcomp018green_esd_hbm_0 comp018green_esd_hbm_0/pn_6p0_CDNS_4066195314552_1/PLUS comp018green_esd_hbm_0/pn_6p0_CDNS_4066195314552_2/PLUS
+ comp018green_esd_hbm_0/pn_6p0_CDNS_4066195314552_3/PLUS comp018green_esd_hbm_0/pn_6p0_CDNS_4066195314552_0/PLUS
+ comp018green_esd_hbm_0/np_6p0_CDNS_4066195314553_0/MINUS comp018green_esd_hbm_0/np_6p0_CDNS_4066195314553_1/MINUS
+ comp018green_esd_hbm_0/np_6p0_CDNS_4066195314553_2/MINUS comp018green_esd_hbm_0/np_6p0_CDNS_4066195314553_3/MINUS
+ np_6p0_CDNS_406619531451_2/MINUS VSUBS comp018green_esd_hbm_0/pn_6p0_CDNS_4066195314552_3/w_n120_n120#
+ comp018green_esd_hbm
.ends

.subckt gf180mcu_fd_io__asig_5p0 VDD DVDD ASIG5V VSS
XGF_NI_ASIG_5P0_BASE_0 DVDD DVDD DVDD VSS VSS DVDD VSS DVDD VSS DVDD VSS VSS DVDD
+ DVDD DVDD VSS DVDD VSS DVDD DVDD VSS DVDD DVDD DVDD DVDD DVDD VSS VDD DVDD DVDD
+ DVDD ASIG5V VSS DVDD DVDD DVDD DVDD VSS VSS DVDD DVDD VSS VSS VSS DVDD DVDD VSS
+ DVDD VSS VSS DVDD VSS VSS DVDD DVDD DVDD VSS VSS VSS DVDD DVDD VSS VSS VSS DVDD
+ VSS VSS DVDD DVDD DVDD DVDD VSS DVDD DVDD VSS ASIG5V DVDD VSS VSS ASIG5V DVDD VSS
+ VSS VSS VDD DVDD DVDD VSS VSS DVDD DVDD DVDD VSS DVDD DVDD VSS DVDD DVDD VSS ASIG5V
+ DVDD VSS ASIG5V DVDD DVDD DVDD DVDD ASIG5V DVDD VSS DVDD ASIG5V DVDD DVDD DVDD VSS
+ DVDD DVDD DVDD DVDD DVDD DVDD VSS ASIG5V DVDD DVDD VSS VSS DVDD DVDD GF_NI_ASIG_5P0_BASE
X0 DVDD VSS cap_nmos_06v0 c_width=15u c_length=15u
X1 DVDD VSS cap_nmos_06v0 c_width=15u c_length=15u
X2 DVDD VSS cap_nmos_06v0 c_width=15u c_length=15u
X3 DVDD VSS cap_nmos_06v0 c_width=15u c_length=15u
X4 DVDD VSS cap_nmos_06v0 c_width=15u c_length=15u
X5 DVDD VSS cap_nmos_06v0 c_width=15u c_length=15u
X6 DVDD VSS cap_nmos_06v0 c_width=15u c_length=15u
X7 DVDD VSS cap_nmos_06v0 c_width=15u c_length=15u
X8 DVDD VSS cap_nmos_06v0 c_width=15u c_length=15u
X9 DVDD VSS cap_nmos_06v0 c_width=15u c_length=15u
X10 DVDD VSS cap_nmos_06v0 c_width=15u c_length=15u
X11 DVDD VSS cap_nmos_06v0 c_width=15u c_length=15u
X12 DVDD VSS cap_nmos_06v0 c_width=15u c_length=15u
X13 DVDD VSS cap_nmos_06v0 c_width=15u c_length=15u
X14 DVDD VSS cap_nmos_06v0 c_width=15u c_length=15u
X15 DVDD VSS cap_nmos_06v0 c_width=15u c_length=15u
X16 DVDD VSS cap_nmos_06v0 c_width=15u c_length=15u
X17 DVDD VSS cap_nmos_06v0 c_width=15u c_length=15u
X18 DVDD VSS cap_nmos_06v0 c_width=15u c_length=15u
X19 DVDD VSS cap_nmos_06v0 c_width=15u c_length=15u
X20 DVDD VSS cap_nmos_06v0 c_width=15u c_length=15u
X21 DVDD VSS cap_nmos_06v0 c_width=15u c_length=15u
X22 DVDD VSS cap_nmos_06v0 c_width=15u c_length=15u
X23 DVDD VSS cap_nmos_06v0 c_width=15u c_length=15u
X24 DVDD VSS cap_nmos_06v0 c_width=15u c_length=15u
X25 DVDD VSS cap_nmos_06v0 c_width=15u c_length=15u
X26 DVDD VSS cap_nmos_06v0 c_width=15u c_length=15u
X27 DVDD VSS cap_nmos_06v0 c_width=15u c_length=15u
X28 DVDD VSS cap_nmos_06v0 c_width=15u c_length=15u
X29 DVDD VSS cap_nmos_06v0 c_width=15u c_length=15u
X30 DVDD VSS cap_nmos_06v0 c_width=15u c_length=15u
X31 DVDD VSS cap_nmos_06v0 c_width=15u c_length=15u
X32 DVDD VSS cap_nmos_06v0 c_width=15u c_length=15u
X33 DVDD VSS cap_nmos_06v0 c_width=15u c_length=15u
X34 DVDD VSS cap_nmos_06v0 c_width=15u c_length=15u
X35 DVDD VSS cap_nmos_06v0 c_width=15u c_length=15u
.ends

.subckt sample_pads ASIG5V DVSS DVDD
Xgf180mcu_fd_io__dvss_0 DVDD DVDD DVSS gf180mcu_fd_io__dvss
Xgf180mcu_fd_io__dvdd_0 DVDD DVSS gf180mcu_fd_io__dvdd
Xgf180mcu_fd_io__fill10_0 DVSS DVDD DVDD DVSS gf180mcu_fd_io__fill10
Xgf180mcu_fd_io__asig_5p0_0 DVDD DVDD ASIG5V DVSS gf180mcu_fd_io__asig_5p0
Xgf180mcu_fd_io__fill10_1 DVSS DVDD DVDD DVSS gf180mcu_fd_io__fill10
.ends
