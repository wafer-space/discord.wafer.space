* NGSPICE file created from annular_fet_potpourri.ext - technology: gf180mcuD

.subckt minimum_annular_nfet4 VSUBS
X0 a_n1459_620r# a_n1559_564# a_n1515_475# VSUBS nfet_03v3 ad=0.3087p pd=2.01u as=0.52065p ps=3.23u w=1.02u l=0.28u
.ends

.subckt minimum_annular_nfet2 a_n1085_461# VSUBS
X0 a_n983_567r# a_n1039_507r# a_n1085_461# VSUBS nfet_03v3 ad=0.31427p pd=2.03u as=1.55732p ps=11.095u w=2.9u l=0.28u
.ends

.subckt minimum_annular_nfet a_697_69# VSUBS
X0 a_799_175r# a_743_115r# a_697_69# VSUBS nfet_03v3 ad=0.31427p pd=2.02u as=1.5918p ps=10.83u w=2.795u l=0.28u
.ends

.subckt minimum_annular_nfet5 VSUBS
X0 a_n936_34r# a_n993_n66# a_n1082_n22# VSUBS nfet_03v3 ad=0.31735p pd=2.05u as=0.52955p ps=3.27u w=1.045u l=0.285u
.ends

.subckt minimum_annular_nfet3 VSUBS
X0 a_n1449_96r# a_n1506_11r# a_n1552_n78# VSUBS nfet_03v3 ad=0.31732p pd=2.05u as=1.35385p ps=8.51u w=2.315u l=0.28u
.ends

.subckt annular_fet_potpourri
Xminimum_annular_nfet4_0 VSUBS minimum_annular_nfet4
Xminimum_annular_nfet2_0 a_n1207_758# VSUBS minimum_annular_nfet2
Xminimum_annular_nfet_2 a_n524_777# VSUBS minimum_annular_nfet
Xminimum_annular_nfet5_0 VSUBS minimum_annular_nfet5
Xminimum_annular_nfet3_0 VSUBS minimum_annular_nfet3
.ends
